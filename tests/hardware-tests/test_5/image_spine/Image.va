// Image Enhancement Test (Image Name: Spine)

// Dependencies
`include "./disciplines.vams" // Natures and disciplines
`include "./constants.vams"   // Common physical and math constants

// Image enhancement fitness function module
module	Image(Req, Ready, Ack, Data0, Data1, Data2, Data3, Data4, Data5, Data6, Data7, Data8, Data9, Data10, Data11, Data12, Data13, Data14, Data15, Out0, Out1, Out2, Out3, Out4, Out5, Out6, Out7, Out8, Out9, Out10, Out11, Out12, Out13, Out14, Out15);

// Declarations
input	Req, Ready, Data0, Data1, Data2, Data3, Data4, Data5, Data6, Data7, Data8, Data9, Data10, Data11, Data12, Data13, Data14, Data15;

output	Ack, Out0, Out1, Out2, Out3, Out4, Out5, Out6, Out7, Out8, Out9, Out10, Out11, Out12, Out13, Out14, Out15;

electrical	Req, Ready, Ack, Data0, Data1, Data2, Data3, Data4, Data5, Data6, Data7, Data8, Data9, Data10, Data11, Data12, Data13, Data14, Data15, Out0, Out1, Out2, Out3, Out4, Out5, Out6, Out7, Out8, Out9, Out10, Out11, Out12, Out13, Out14, Out15;

real	r_image, gamma, gammafraction, onethird, p_fitness, fitness, sobel, hsobel, vsobel, entropy, pixel, average, std, x, y, d0, d1, d2, d3, d4, d5, d6, d7, d8, d9, d10, d11, d12, d13, d14, d15, d_image, p_image[1:51939], image[1:51939];

integer	row, counter, counter2, imagecolumns, imagerows, imagepixels;

analog begin

imagecolumns=199;
imagerows=261;
imagepixels=51939;

// When Req signal is set
@(cross (V(Req)-1.6,+1))	begin

//Reading Image
image[1]=0; image[2]=1; image[3]=1; image[4]=1; image[5]=1; image[6]=1; image[7]=1; image[8]=1; image[9]=1; image[10]=1; image[11]=0; image[12]=1; image[13]=1; image[14]=1; image[15]=0; image[16]=1; image[17]=1; image[18]=1; image[19]=0; image[20]=1; image[21]=1; image[22]=1; image[23]=1; image[24]=1; image[25]=1; image[26]=1; image[27]=1; image[28]=1; image[29]=1; image[30]=1; image[31]=1; image[32]=1; image[33]=1; image[34]=1; image[35]=1; image[36]=1; image[37]=1; image[38]=1; image[39]=1; image[40]=1; image[41]=1; image[42]=1; image[43]=1; image[44]=1; image[45]=1; image[46]=1; image[47]=2; image[48]=2; image[49]=3; image[50]=3; image[51]=2; image[52]=2; image[53]=3; image[54]=4; image[55]=4; image[56]=3; image[57]=2; image[58]=3; image[59]=4; image[60]=4; image[61]=5; image[62]=10; image[63]=11; image[64]=14; image[65]=14; image[66]=11; image[67]=7; image[68]=6; image[69]=8; image[70]=16; image[71]=15; image[72]=9; image[73]=15; image[74]=39; image[75]=55; image[76]=42; image[77]=43; image[78]=32; image[79]=20; image[80]=17; image[81]=16; image[82]=16; image[83]=13; image[84]=14; image[85]=19; image[86]=32; image[87]=46; image[88]=53; image[89]=37; image[90]=51; image[91]=107; image[92]=125; image[93]=139; image[94]=98; image[95]=57; image[96]=47; image[97]=56; image[98]=58; image[99]=54; image[100]=58; image[101]=62; image[102]=99; image[103]=148; image[104]=148; image[105]=108; image[106]=56; image[107]=40; image[108]=42; image[109]=34; image[110]=46; image[111]=64; image[112]=80; image[113]=135; image[114]=159; image[115]=113; image[116]=95; image[117]=191; image[118]=255; image[119]=255; image[120]=255; image[121]=255; image[122]=255; image[123]=255; image[124]=205; image[125]=59; image[126]=43; image[127]=38; image[128]=7; image[129]=1; image[130]=1; image[131]=1; image[132]=1; image[133]=1; image[134]=1; image[135]=1; image[136]=0; image[137]=1; image[138]=1; image[139]=1; image[140]=1; image[141]=1; image[142]=1; image[143]=1; image[144]=1; image[145]=1; image[146]=1; image[147]=1; image[148]=1; image[149]=1; image[150]=1; image[151]=1; image[152]=1; image[153]=1; image[154]=1; image[155]=1; image[156]=1; image[157]=1; image[158]=1; image[159]=1; image[160]=1; image[161]=1; image[162]=1; image[163]=1; image[164]=1; image[165]=1; image[166]=1; image[167]=1; image[168]=1; image[169]=1; image[170]=1; image[171]=1; image[172]=1; image[173]=1; image[174]=1; image[175]=1; image[176]=1; image[177]=1; image[178]=1; image[179]=1; image[180]=1; image[181]=1; image[182]=1; image[183]=1; image[184]=1; image[185]=1; image[186]=1; image[187]=1; image[188]=0; image[189]=1; image[190]=1; image[191]=1; image[192]=1; image[193]=1; image[194]=0; image[195]=0; image[196]=1; image[197]=1; image[198]=1; image[199]=1; image[200]=1; image[201]=1; image[202]=1; image[203]=1; image[204]=0; image[205]=1; image[206]=1; image[207]=1; image[208]=1; image[209]=1; image[210]=1; image[211]=1; image[212]=1; image[213]=1; image[214]=1; image[215]=1; image[216]=1; image[217]=1; image[218]=1; image[219]=1; image[220]=1; image[221]=1; image[222]=1; image[223]=1; image[224]=1; image[225]=1; image[226]=1; image[227]=1; image[228]=1; image[229]=1; image[230]=1; image[231]=1; image[232]=1; image[233]=1; image[234]=1; image[235]=1; image[236]=1; image[237]=1; image[238]=1; image[239]=1; image[240]=1; image[241]=1; image[242]=1; image[243]=1; image[244]=1; image[245]=1; image[246]=2; image[247]=2; image[248]=3; image[249]=3; image[250]=2; image[251]=2; image[252]=3; image[253]=4; image[254]=5; image[255]=4; image[256]=3; image[257]=3; image[258]=4; image[259]=4; image[260]=6; image[261]=12; image[262]=12; image[263]=10; image[264]=9; image[265]=8; image[266]=8; image[267]=11; image[268]=15; image[269]=19; image[270]=19; image[271]=13; image[272]=17; image[273]=44; image[274]=63; image[275]=48; image[276]=43; image[277]=37; image[278]=27; image[279]=20; image[280]=17; image[281]=16; image[282]=13; image[283]=12; image[284]=12; image[285]=25; image[286]=47; image[287]=61; image[288]=44; image[289]=50; image[290]=107; image[291]=139; image[292]=155; image[293]=137; image[294]=86; image[295]=55; image[296]=62; image[297]=66; image[298]=64; image[299]=67; image[300]=66; image[301]=89; image[302]=150; image[303]=198; image[304]=156; image[305]=73; image[306]=49; image[307]=50; image[308]=38; image[309]=43; image[310]=63; image[311]=79; image[312]=124; image[313]=141; image[314]=123; image[315]=145; image[316]=246; image[317]=255; image[318]=255; image[319]=255; image[320]=255; image[321]=255; image[322]=255; image[323]=253; image[324]=161; image[325]=54; image[326]=49; image[327]=30; image[328]=7; image[329]=1; image[330]=1; image[331]=1; image[332]=1; image[333]=1; image[334]=2; image[335]=1; image[336]=0; image[337]=1; image[338]=1; image[339]=1; image[340]=1; image[341]=1; image[342]=1; image[343]=1; image[344]=1; image[345]=1; image[346]=1; image[347]=1; image[348]=1; image[349]=1; image[350]=1; image[351]=1; image[352]=1; image[353]=1; image[354]=1; image[355]=1; image[356]=1; image[357]=1; image[358]=1; image[359]=1; image[360]=1; image[361]=1; image[362]=1; image[363]=1; image[364]=1; image[365]=1; image[366]=1; image[367]=1; image[368]=1; image[369]=1; image[370]=1; image[371]=1; image[372]=1; image[373]=1; image[374]=1; image[375]=1; image[376]=1; image[377]=1; image[378]=1; image[379]=1; image[380]=1; image[381]=1; image[382]=1; image[383]=1; image[384]=1; image[385]=1; image[386]=1; image[387]=1; image[388]=1; image[389]=1; image[390]=1; image[391]=1; image[392]=1; image[393]=1; image[394]=1; image[395]=1; image[396]=1; image[397]=1; image[398]=1; image[399]=1; image[400]=1; image[401]=1; image[402]=1; image[403]=1; image[404]=1; image[405]=1; image[406]=1; image[407]=1; image[408]=1; image[409]=1; image[410]=1; image[411]=1; image[412]=1; image[413]=1; image[414]=1; image[415]=1; image[416]=1; image[417]=1; image[418]=1; image[419]=1; image[420]=1; image[421]=1; image[422]=1; image[423]=1; image[424]=1; image[425]=1; image[426]=1; image[427]=2; image[428]=1; image[429]=1; image[430]=1; image[431]=1; image[432]=1; image[433]=1; image[434]=1; image[435]=1; image[436]=1; image[437]=1; image[438]=1; image[439]=1; image[440]=1; image[441]=1; image[442]=1; image[443]=1; image[444]=1; image[445]=1; image[446]=2; image[447]=3; image[448]=3; image[449]=3; image[450]=3; image[451]=3; image[452]=4; image[453]=5; image[454]=5; image[455]=3; image[456]=3; image[457]=4; image[458]=5; image[459]=6; image[460]=9; image[461]=7; image[462]=5; image[463]=8; image[464]=11; image[465]=15; image[466]=20; image[467]=23; image[468]=22; image[469]=23; image[470]=17; image[471]=19; image[472]=46; image[473]=69; image[474]=53; image[475]=42; image[476]=39; image[477]=35; image[478]=26; image[479]=17; image[480]=11; image[481]=8; image[482]=8; image[483]=9; image[484]=20; image[485]=35; image[486]=43; image[487]=48; image[488]=53; image[489]=95; image[490]=119; image[491]=138; image[492]=165; image[493]=115; image[494]=63; image[495]=66; image[496]=78; image[497]=82; image[498]=77; image[499]=76; image[500]=79; image[501]=117; image[502]=227; image[503]=231; image[504]=120; image[505]=62; image[506]=55; image[507]=40; image[508]=40; image[509]=56; image[510]=76; image[511]=134; image[512]=187; image[513]=204; image[514]=228; image[515]=255; image[516]=255; image[517]=255; image[518]=255; image[519]=255; image[520]=255; image[521]=255; image[522]=255; image[523]=255; image[524]=103; image[525]=43; image[526]=67; image[527]=19; image[528]=2; image[529]=1; image[530]=1; image[531]=1; image[532]=1; image[533]=1; image[534]=1; image[535]=1; image[536]=1; image[537]=1; image[538]=1; image[539]=1; image[540]=1; image[541]=1; image[542]=1; image[543]=1; image[544]=1; image[545]=1; image[546]=1; image[547]=1; image[548]=1; image[549]=1; image[550]=1; image[551]=1; image[552]=1; image[553]=1; image[554]=1; image[555]=1; image[556]=1; image[557]=1; image[558]=1; image[559]=1; image[560]=1; image[561]=1; image[562]=1; image[563]=1; image[564]=1; image[565]=1; image[566]=1; image[567]=1; image[568]=1; image[569]=1; image[570]=1; image[571]=1; image[572]=1; image[573]=1; image[574]=1; image[575]=1; image[576]=1; image[577]=1; image[578]=1; image[579]=1; image[580]=1; image[581]=1; image[582]=1; image[583]=1; image[584]=1; image[585]=1; image[586]=1; image[587]=1; image[588]=1; image[589]=1; image[590]=1; image[591]=1; image[592]=1; image[593]=1; image[594]=1; image[595]=1; image[596]=1; image[597]=1; image[598]=2; image[599]=1; image[600]=1; image[601]=1; image[602]=1; image[603]=1; image[604]=1; image[605]=1; image[606]=1; image[607]=1; image[608]=1; image[609]=1; image[610]=1; image[611]=1; image[612]=1; image[613]=1; image[614]=1; image[615]=1; image[616]=1; image[617]=1; image[618]=1; image[619]=1; image[620]=1; image[621]=1; image[622]=1; image[623]=1; image[624]=1; image[625]=1; image[626]=1; image[627]=1; image[628]=1; image[629]=1; image[630]=1; image[631]=1; image[632]=1; image[633]=1; image[634]=1; image[635]=1; image[636]=1; image[637]=1; image[638]=1; image[639]=1; image[640]=1; image[641]=1; image[642]=1; image[643]=1; image[644]=1; image[645]=1; image[646]=2; image[647]=3; image[648]=3; image[649]=3; image[650]=3; image[651]=4; image[652]=6; image[653]=5; image[654]=4; image[655]=4; image[656]=3; image[657]=3; image[658]=3; image[659]=3; image[660]=5; image[661]=9; image[662]=17; image[663]=20; image[664]=23; image[665]=23; image[666]=24; image[667]=23; image[668]=24; image[669]=23; image[670]=16; image[671]=46; image[672]=77; image[673]=57; image[674]=46; image[675]=37; image[676]=37; image[677]=31; image[678]=23; image[679]=14; image[680]=4; image[681]=4; image[682]=5; image[683]=12; image[684]=33; image[685]=58; image[686]=87; image[687]=82; image[688]=74; image[689]=86; image[690]=113; image[691]=154; image[692]=147; image[693]=109; image[694]=59; image[695]=65; image[696]=82; image[697]=73; image[698]=75; image[699]=86; image[700]=109; image[701]=197; image[702]=255; image[703]=229; image[704]=121; image[705]=83; image[706]=61; image[707]=48; image[708]=52; image[709]=48; image[710]=74; image[711]=131; image[712]=192; image[713]=240; image[714]=255; image[715]=255; image[716]=255; image[717]=255; image[718]=255; image[719]=255; image[720]=255; image[721]=255; image[722]=255; image[723]=239; image[724]=150; image[725]=113; image[726]=69; image[727]=11; image[728]=1; image[729]=1; image[730]=1; image[731]=1; image[732]=1; image[733]=1; image[734]=1; image[735]=1; image[736]=1; image[737]=1; image[738]=1; image[739]=1; image[740]=1; image[741]=1; image[742]=1; image[743]=1; image[744]=1; image[745]=1; image[746]=1; image[747]=1; image[748]=1; image[749]=1; image[750]=1; image[751]=1; image[752]=1; image[753]=1; image[754]=1; image[755]=1; image[756]=1; image[757]=1; image[758]=1; image[759]=1; image[760]=1; image[761]=1; image[762]=1; image[763]=1; image[764]=1; image[765]=1; image[766]=1; image[767]=1; image[768]=1; image[769]=1; image[770]=1; image[771]=1; image[772]=1; image[773]=1; image[774]=1; image[775]=1; image[776]=1; image[777]=1; image[778]=1; image[779]=1; image[780]=1; image[781]=1; image[782]=1; image[783]=0; image[784]=1; image[785]=1; image[786]=1; image[787]=1; image[788]=1; image[789]=1; image[790]=1; image[791]=1; image[792]=1; image[793]=1; image[794]=1; image[795]=1; image[796]=1; image[797]=2; image[798]=2; image[799]=1; image[800]=1; image[801]=1; image[802]=1; image[803]=1; image[804]=1; image[805]=1; image[806]=1; image[807]=1; image[808]=1; image[809]=1; image[810]=1; image[811]=1; image[812]=1; image[813]=1; image[814]=1; image[815]=1; image[816]=1; image[817]=1; image[818]=1; image[819]=1; image[820]=1; image[821]=1; image[822]=1; image[823]=1; image[824]=1; image[825]=1; image[826]=1; image[827]=1; image[828]=1; image[829]=1; image[830]=1; image[831]=1; image[832]=1; image[833]=1; image[834]=1; image[835]=1; image[836]=1; image[837]=1; image[838]=1; image[839]=1; image[840]=1; image[841]=1; image[842]=1; image[843]=2; image[844]=1; image[845]=1; image[846]=2; image[847]=2; image[848]=3; image[849]=3; image[850]=4; image[851]=5; image[852]=4; image[853]=4; image[854]=4; image[855]=4; image[856]=4; image[857]=3; image[858]=4; image[859]=10; image[860]=17; image[861]=22; image[862]=22; image[863]=23; image[864]=22; image[865]=22; image[866]=21; image[867]=22; image[868]=23; image[869]=15; image[870]=43; image[871]=88; image[872]=65; image[873]=49; image[874]=36; image[875]=36; image[876]=32; image[877]=31; image[878]=18; image[879]=4; image[880]=4; image[881]=5; image[882]=10; image[883]=26; image[884]=50; image[885]=99; image[886]=107; image[887]=97; image[888]=112; image[889]=127; image[890]=130; image[891]=150; image[892]=137; image[893]=64; image[894]=62; image[895]=73; image[896]=72; image[897]=75; image[898]=82; image[899]=101; image[900]=145; image[901]=228; image[902]=243; image[903]=164; image[904]=108; image[905]=81; image[906]=61; image[907]=67; image[908]=61; image[909]=63; image[910]=75; image[911]=109; image[912]=178; image[913]=248; image[914]=255; image[915]=255; image[916]=255; image[917]=255; image[918]=255; image[919]=255; image[920]=255; image[921]=255; image[922]=255; image[923]=216; image[924]=123; image[925]=105; image[926]=41; image[927]=6; image[928]=1; image[929]=1; image[930]=1; image[931]=1; image[932]=1; image[933]=1; image[934]=1; image[935]=1; image[936]=1; image[937]=1; image[938]=1; image[939]=1; image[940]=1; image[941]=1; image[942]=1; image[943]=1; image[944]=1; image[945]=1; image[946]=1; image[947]=1; image[948]=1; image[949]=1; image[950]=1; image[951]=1; image[952]=1; image[953]=1; image[954]=1; image[955]=1; image[956]=1; image[957]=1; image[958]=1; image[959]=1; image[960]=1; image[961]=1; image[962]=1; image[963]=1; image[964]=1; image[965]=1; image[966]=1; image[967]=1; image[968]=1; image[969]=1; image[970]=1; image[971]=1; image[972]=1; image[973]=1; image[974]=1; image[975]=1; image[976]=1; image[977]=1; image[978]=1; image[979]=1; image[980]=1; image[981]=1; image[982]=1; image[983]=1; image[984]=1; image[985]=1; image[986]=1; image[987]=1; image[988]=1; image[989]=1; image[990]=1; image[991]=1; image[992]=1; image[993]=1; image[994]=1; image[995]=1; image[996]=1; image[997]=1; image[998]=1; image[999]=1; image[1000]=1; image[1001]=1; image[1002]=1; image[1003]=1; image[1004]=1; image[1005]=1; image[1006]=1; image[1007]=1; image[1008]=1; image[1009]=1; image[1010]=1; image[1011]=1; image[1012]=1; image[1013]=1; image[1014]=1; image[1015]=1; image[1016]=1; image[1017]=1; image[1018]=1; image[1019]=1; image[1020]=1; image[1021]=1; image[1022]=1; image[1023]=1; image[1024]=2; image[1025]=1; image[1026]=1; image[1027]=1; image[1028]=1; image[1029]=1; image[1030]=1; image[1031]=1; image[1032]=1; image[1033]=1; image[1034]=1; image[1035]=1; image[1036]=1; image[1037]=1; image[1038]=1; image[1039]=1; image[1040]=1; image[1041]=1; image[1042]=2; image[1043]=2; image[1044]=1; image[1045]=1; image[1046]=3; image[1047]=3; image[1048]=3; image[1049]=3; image[1050]=5; image[1051]=6; image[1052]=3; image[1053]=5; image[1054]=5; image[1055]=6; image[1056]=8; image[1057]=10; image[1058]=14; image[1059]=18; image[1060]=27; image[1061]=26; image[1062]=20; image[1063]=18; image[1064]=18; image[1065]=20; image[1066]=20; image[1067]=19; image[1068]=14; image[1069]=35; image[1070]=83; image[1071]=81; image[1072]=57; image[1073]=37; image[1074]=40; image[1075]=33; image[1076]=46; image[1077]=32; image[1078]=10; image[1079]=6; image[1080]=4; image[1081]=6; image[1082]=11; image[1083]=19; image[1084]=64; image[1085]=86; image[1086]=106; image[1087]=166; image[1088]=167; image[1089]=82; image[1090]=91; image[1091]=134; image[1092]=116; image[1093]=93; image[1094]=81; image[1095]=87; image[1096]=82; image[1097]=82; image[1098]=96; image[1099]=109; image[1100]=119; image[1101]=172; image[1102]=217; image[1103]=178; image[1104]=148; image[1105]=131; image[1106]=106; image[1107]=87; image[1108]=103; image[1109]=99; image[1110]=74; image[1111]=94; image[1112]=144; image[1113]=244; image[1114]=255; image[1115]=255; image[1116]=255; image[1117]=237; image[1118]=246; image[1119]=255; image[1120]=255; image[1121]=255; image[1122]=255; image[1123]=177; image[1124]=111; image[1125]=97; image[1126]=32; image[1127]=6; image[1128]=1; image[1129]=1; image[1130]=1; image[1131]=1; image[1132]=2; image[1133]=2; image[1134]=1; image[1135]=1; image[1136]=1; image[1137]=1; image[1138]=1; image[1139]=1; image[1140]=1; image[1141]=1; image[1142]=1; image[1143]=1; image[1144]=1; image[1145]=1; image[1146]=1; image[1147]=1; image[1148]=1; image[1149]=1; image[1150]=1; image[1151]=1; image[1152]=1; image[1153]=1; image[1154]=1; image[1155]=1; image[1156]=1; image[1157]=1; image[1158]=1; image[1159]=1; image[1160]=1; image[1161]=1; image[1162]=1; image[1163]=1; image[1164]=1; image[1165]=1; image[1166]=1; image[1167]=1; image[1168]=1; image[1169]=1; image[1170]=1; image[1171]=1; image[1172]=1; image[1173]=1; image[1174]=1; image[1175]=1; image[1176]=1; image[1177]=1; image[1178]=1; image[1179]=1; image[1180]=1; image[1181]=1; image[1182]=1; image[1183]=1; image[1184]=1; image[1185]=1; image[1186]=1; image[1187]=1; image[1188]=1; image[1189]=1; image[1190]=1; image[1191]=1; image[1192]=1; image[1193]=1; image[1194]=1; image[1195]=1; image[1196]=1; image[1197]=1; image[1198]=1; image[1199]=1; image[1200]=1; image[1201]=1; image[1202]=1; image[1203]=1; image[1204]=1; image[1205]=1; image[1206]=1; image[1207]=1; image[1208]=1; image[1209]=1; image[1210]=1; image[1211]=1; image[1212]=1; image[1213]=1; image[1214]=1; image[1215]=1; image[1216]=1; image[1217]=1; image[1218]=1; image[1219]=1; image[1220]=1; image[1221]=1; image[1222]=1; image[1223]=1; image[1224]=1; image[1225]=1; image[1226]=1; image[1227]=1; image[1228]=1; image[1229]=1; image[1230]=1; image[1231]=1; image[1232]=1; image[1233]=1; image[1234]=1; image[1235]=1; image[1236]=1; image[1237]=1; image[1238]=1; image[1239]=1; image[1240]=1; image[1241]=1; image[1242]=2; image[1243]=2; image[1244]=2; image[1245]=3; image[1246]=3; image[1247]=3; image[1248]=3; image[1249]=5; image[1250]=6; image[1251]=5; image[1252]=4; image[1253]=4; image[1254]=5; image[1255]=7; image[1256]=10; image[1257]=14; image[1258]=15; image[1259]=19; image[1260]=21; image[1261]=18; image[1262]=16; image[1263]=17; image[1264]=15; image[1265]=16; image[1266]=18; image[1267]=14; image[1268]=26; image[1269]=64; image[1270]=73; image[1271]=59; image[1272]=40; image[1273]=44; image[1274]=41; image[1275]=47; image[1276]=34; image[1277]=15; image[1278]=8; image[1279]=5; image[1280]=4; image[1281]=13; image[1282]=25; image[1283]=68; image[1284]=76; image[1285]=75; image[1286]=121; image[1287]=148; image[1288]=142; image[1289]=94; image[1290]=88; image[1291]=112; image[1292]=98; image[1293]=77; image[1294]=86; image[1295]=90; image[1296]=80; image[1297]=80; image[1298]=94; image[1299]=96; image[1300]=111; image[1301]=177; image[1302]=230; image[1303]=232; image[1304]=215; image[1305]=197; image[1306]=158; image[1307]=121; image[1308]=136; image[1309]=138; image[1310]=115; image[1311]=113; image[1312]=192; image[1313]=255; image[1314]=255; image[1315]=255; image[1316]=229; image[1317]=218; image[1318]=254; image[1319]=255; image[1320]=255; image[1321]=255; image[1322]=250; image[1323]=172; image[1324]=115; image[1325]=94; image[1326]=22; image[1327]=3; image[1328]=1; image[1329]=1; image[1330]=1; image[1331]=1; image[1332]=1; image[1333]=1; image[1334]=1; image[1335]=1; image[1336]=1; image[1337]=1; image[1338]=1; image[1339]=1; image[1340]=1; image[1341]=1; image[1342]=1; image[1343]=1; image[1344]=1; image[1345]=1; image[1346]=1; image[1347]=1; image[1348]=2; image[1349]=1; image[1350]=1; image[1351]=1; image[1352]=1; image[1353]=1; image[1354]=1; image[1355]=1; image[1356]=1; image[1357]=2; image[1358]=1; image[1359]=1; image[1360]=1; image[1361]=1; image[1362]=1; image[1363]=1; image[1364]=1; image[1365]=1; image[1366]=1; image[1367]=1; image[1368]=1; image[1369]=1; image[1370]=1; image[1371]=1; image[1372]=1; image[1373]=1; image[1374]=1; image[1375]=1; image[1376]=1; image[1377]=1; image[1378]=1; image[1379]=1; image[1380]=1; image[1381]=1; image[1382]=1; image[1383]=1; image[1384]=1; image[1385]=1; image[1386]=1; image[1387]=1; image[1388]=1; image[1389]=1; image[1390]=1; image[1391]=1; image[1392]=1; image[1393]=1; image[1394]=1; image[1395]=1; image[1396]=1; image[1397]=1; image[1398]=1; image[1399]=1; image[1400]=1; image[1401]=1; image[1402]=1; image[1403]=1; image[1404]=1; image[1405]=1; image[1406]=1; image[1407]=1; image[1408]=1; image[1409]=1; image[1410]=1; image[1411]=1; image[1412]=1; image[1413]=1; image[1414]=1; image[1415]=1; image[1416]=1; image[1417]=1; image[1418]=1; image[1419]=1; image[1420]=2; image[1421]=1; image[1422]=1; image[1423]=1; image[1424]=1; image[1425]=1; image[1426]=1; image[1427]=1; image[1428]=1; image[1429]=1; image[1430]=1; image[1431]=1; image[1432]=1; image[1433]=1; image[1434]=1; image[1435]=1; image[1436]=1; image[1437]=1; image[1438]=1; image[1439]=1; image[1440]=1; image[1441]=2; image[1442]=2; image[1443]=2; image[1444]=2; image[1445]=3; image[1446]=3; image[1447]=4; image[1448]=4; image[1449]=6; image[1450]=5; image[1451]=4; image[1452]=5; image[1453]=6; image[1454]=5; image[1455]=8; image[1456]=14; image[1457]=15; image[1458]=14; image[1459]=17; image[1460]=20; image[1461]=17; image[1462]=16; image[1463]=16; image[1464]=18; image[1465]=20; image[1466]=14; image[1467]=21; image[1468]=62; image[1469]=76; image[1470]=60; image[1471]=41; image[1472]=49; image[1473]=47; image[1474]=45; image[1475]=32; image[1476]=18; image[1477]=11; image[1478]=5; image[1479]=6; image[1480]=21; image[1481]=38; image[1482]=78; image[1483]=85; image[1484]=79; image[1485]=98; image[1486]=115; image[1487]=194; image[1488]=143; image[1489]=83; image[1490]=103; image[1491]=108; image[1492]=79; image[1493]=78; image[1494]=92; image[1495]=82; image[1496]=72; image[1497]=74; image[1498]=80; image[1499]=85; image[1500]=119; image[1501]=219; image[1502]=255; image[1503]=253; image[1504]=255; image[1505]=225; image[1506]=150; image[1507]=137; image[1508]=176; image[1509]=169; image[1510]=146; image[1511]=174; image[1512]=231; image[1513]=255; image[1514]=255; image[1515]=254; image[1516]=246; image[1517]=252; image[1518]=255; image[1519]=255; image[1520]=255; image[1521]=255; image[1522]=234; image[1523]=127; image[1524]=135; image[1525]=52; image[1526]=7; image[1527]=1; image[1528]=1; image[1529]=1; image[1530]=1; image[1531]=1; image[1532]=1; image[1533]=1; image[1534]=1; image[1535]=1; image[1536]=1; image[1537]=1; image[1538]=1; image[1539]=1; image[1540]=1; image[1541]=1; image[1542]=1; image[1543]=1; image[1544]=1; image[1545]=1; image[1546]=1; image[1547]=1; image[1548]=1; image[1549]=1; image[1550]=1; image[1551]=1; image[1552]=1; image[1553]=1; image[1554]=1; image[1555]=1; image[1556]=1; image[1557]=1; image[1558]=1; image[1559]=1; image[1560]=1; image[1561]=1; image[1562]=1; image[1563]=1; image[1564]=1; image[1565]=1; image[1566]=1; image[1567]=1; image[1568]=1; image[1569]=1; image[1570]=1; image[1571]=1; image[1572]=1; image[1573]=1; image[1574]=1; image[1575]=1; image[1576]=1; image[1577]=1; image[1578]=1; image[1579]=1; image[1580]=1; image[1581]=1; image[1582]=1; image[1583]=1; image[1584]=1; image[1585]=1; image[1586]=1; image[1587]=1; image[1588]=1; image[1589]=1; image[1590]=1; image[1591]=1; image[1592]=1; image[1593]=1; image[1594]=1; image[1595]=1; image[1596]=1; image[1597]=1; image[1598]=1; image[1599]=1; image[1600]=1; image[1601]=1; image[1602]=1; image[1603]=1; image[1604]=1; image[1605]=1; image[1606]=1; image[1607]=1; image[1608]=1; image[1609]=1; image[1610]=1; image[1611]=1; image[1612]=1; image[1613]=1; image[1614]=1; image[1615]=1; image[1616]=1; image[1617]=1; image[1618]=1; image[1619]=1; image[1620]=1; image[1621]=1; image[1622]=1; image[1623]=1; image[1624]=1; image[1625]=1; image[1626]=1; image[1627]=1; image[1628]=1; image[1629]=1; image[1630]=1; image[1631]=1; image[1632]=1; image[1633]=1; image[1634]=1; image[1635]=1; image[1636]=1; image[1637]=1; image[1638]=1; image[1639]=1; image[1640]=2; image[1641]=2; image[1642]=2; image[1643]=2; image[1644]=2; image[1645]=2; image[1646]=3; image[1647]=3; image[1648]=5; image[1649]=6; image[1650]=6; image[1651]=5; image[1652]=7; image[1653]=8; image[1654]=7; image[1655]=12; image[1656]=15; image[1657]=16; image[1658]=18; image[1659]=25; image[1660]=23; image[1661]=21; image[1662]=22; image[1663]=21; image[1664]=19; image[1665]=17; image[1666]=17; image[1667]=31; image[1668]=79; image[1669]=74; image[1670]=35; image[1671]=48; image[1672]=52; image[1673]=51; image[1674]=46; image[1675]=36; image[1676]=22; image[1677]=14; image[1678]=14; image[1679]=37; image[1680]=68; image[1681]=116; image[1682]=125; image[1683]=94; image[1684]=97; image[1685]=93; image[1686]=120; image[1687]=141; image[1688]=136; image[1689]=116; image[1690]=119; image[1691]=109; image[1692]=74; image[1693]=85; image[1694]=84; image[1695]=69; image[1696]=64; image[1697]=74; image[1698]=83; image[1699]=94; image[1700]=143; image[1701]=182; image[1702]=238; image[1703]=255; image[1704]=213; image[1705]=183; image[1706]=132; image[1707]=107; image[1708]=144; image[1709]=170; image[1710]=167; image[1711]=161; image[1712]=210; image[1713]=252; image[1714]=255; image[1715]=255; image[1716]=255; image[1717]=255; image[1718]=255; image[1719]=255; image[1720]=255; image[1721]=255; image[1722]=241; image[1723]=133; image[1724]=114; image[1725]=25; image[1726]=4; image[1727]=2; image[1728]=1; image[1729]=1; image[1730]=1; image[1731]=1; image[1732]=1; image[1733]=2; image[1734]=1; image[1735]=1; image[1736]=1; image[1737]=1; image[1738]=1; image[1739]=1; image[1740]=1; image[1741]=1; image[1742]=1; image[1743]=1; image[1744]=1; image[1745]=1; image[1746]=1; image[1747]=1; image[1748]=1; image[1749]=1; image[1750]=1; image[1751]=1; image[1752]=1; image[1753]=1; image[1754]=1; image[1755]=1; image[1756]=1; image[1757]=1; image[1758]=1; image[1759]=1; image[1760]=1; image[1761]=1; image[1762]=1; image[1763]=1; image[1764]=1; image[1765]=1; image[1766]=1; image[1767]=1; image[1768]=1; image[1769]=1; image[1770]=1; image[1771]=1; image[1772]=1; image[1773]=1; image[1774]=1; image[1775]=1; image[1776]=1; image[1777]=1; image[1778]=1; image[1779]=1; image[1780]=1; image[1781]=1; image[1782]=1; image[1783]=1; image[1784]=1; image[1785]=1; image[1786]=1; image[1787]=1; image[1788]=1; image[1789]=1; image[1790]=1; image[1791]=1; image[1792]=1; image[1793]=1; image[1794]=1; image[1795]=1; image[1796]=1; image[1797]=1; image[1798]=1; image[1799]=1; image[1800]=1; image[1801]=1; image[1802]=1; image[1803]=1; image[1804]=1; image[1805]=1; image[1806]=1; image[1807]=1; image[1808]=1; image[1809]=1; image[1810]=1; image[1811]=1; image[1812]=1; image[1813]=1; image[1814]=1; image[1815]=1; image[1816]=1; image[1817]=1; image[1818]=1; image[1819]=1; image[1820]=1; image[1821]=1; image[1822]=1; image[1823]=1; image[1824]=1; image[1825]=1; image[1826]=1; image[1827]=1; image[1828]=1; image[1829]=1; image[1830]=1; image[1831]=1; image[1832]=1; image[1833]=1; image[1834]=1; image[1835]=1; image[1836]=1; image[1837]=1; image[1838]=1; image[1839]=1; image[1840]=2; image[1841]=2; image[1842]=2; image[1843]=2; image[1844]=2; image[1845]=3; image[1846]=3; image[1847]=4; image[1848]=6; image[1849]=6; image[1850]=4; image[1851]=5; image[1852]=7; image[1853]=7; image[1854]=11; image[1855]=15; image[1856]=20; image[1857]=22; image[1858]=23; image[1859]=22; image[1860]=22; image[1861]=21; image[1862]=18; image[1863]=17; image[1864]=19; image[1865]=17; image[1866]=13; image[1867]=56; image[1868]=79; image[1869]=51; image[1870]=51; image[1871]=50; image[1872]=48; image[1873]=45; image[1874]=41; image[1875]=33; image[1876]=26; image[1877]=17; image[1878]=30; image[1879]=58; image[1880]=103; image[1881]=113; image[1882]=96; image[1883]=86; image[1884]=89; image[1885]=110; image[1886]=123; image[1887]=136; image[1888]=110; image[1889]=98; image[1890]=101; image[1891]=84; image[1892]=94; image[1893]=98; image[1894]=81; image[1895]=72; image[1896]=74; image[1897]=82; image[1898]=81; image[1899]=100; image[1900]=133; image[1901]=174; image[1902]=245; image[1903]=248; image[1904]=229; image[1905]=172; image[1906]=115; image[1907]=118; image[1908]=139; image[1909]=176; image[1910]=208; image[1911]=201; image[1912]=248; image[1913]=255; image[1914]=255; image[1915]=255; image[1916]=255; image[1917]=255; image[1918]=255; image[1919]=255; image[1920]=255; image[1921]=245; image[1922]=145; image[1923]=123; image[1924]=74; image[1925]=15; image[1926]=2; image[1927]=1; image[1928]=1; image[1929]=1; image[1930]=1; image[1931]=1; image[1932]=2; image[1933]=1; image[1934]=1; image[1935]=1; image[1936]=1; image[1937]=1; image[1938]=1; image[1939]=1; image[1940]=1; image[1941]=1; image[1942]=1; image[1943]=1; image[1944]=1; image[1945]=1; image[1946]=1; image[1947]=1; image[1948]=1; image[1949]=1; image[1950]=1; image[1951]=1; image[1952]=1; image[1953]=1; image[1954]=1; image[1955]=1; image[1956]=1; image[1957]=1; image[1958]=1; image[1959]=1; image[1960]=1; image[1961]=1; image[1962]=1; image[1963]=1; image[1964]=1; image[1965]=1; image[1966]=1; image[1967]=1; image[1968]=1; image[1969]=1; image[1970]=1; image[1971]=1; image[1972]=1; image[1973]=1; image[1974]=1; image[1975]=1; image[1976]=1; image[1977]=1; image[1978]=1; image[1979]=1; image[1980]=1; image[1981]=1; image[1982]=1; image[1983]=1; image[1984]=1; image[1985]=1; image[1986]=1; image[1987]=1; image[1988]=1; image[1989]=1; image[1990]=1; image[1991]=1; image[1992]=1; image[1993]=1; image[1994]=1; image[1995]=1; image[1996]=1; image[1997]=1; image[1998]=1; image[1999]=1; image[2000]=1; image[2001]=1; image[2002]=1; image[2003]=1; image[2004]=1; image[2005]=1; image[2006]=1; image[2007]=1; image[2008]=1; image[2009]=1; image[2010]=1; image[2011]=1; image[2012]=1; image[2013]=1; image[2014]=1; image[2015]=1; image[2016]=1; image[2017]=1; image[2018]=1; image[2019]=1; image[2020]=1; image[2021]=1; image[2022]=1; image[2023]=1; image[2024]=1; image[2025]=2; image[2026]=1; image[2027]=1; image[2028]=1; image[2029]=1; image[2030]=1; image[2031]=1; image[2032]=1; image[2033]=1; image[2034]=1; image[2035]=1; image[2036]=1; image[2037]=1; image[2038]=2; image[2039]=1; image[2040]=2; image[2041]=2; image[2042]=2; image[2043]=2; image[2044]=2; image[2045]=4; image[2046]=4; image[2047]=6; image[2048]=5; image[2049]=5; image[2050]=5; image[2051]=5; image[2052]=8; image[2053]=13; image[2054]=18; image[2055]=21; image[2056]=24; image[2057]=22; image[2058]=21; image[2059]=22; image[2060]=19; image[2061]=18; image[2062]=18; image[2063]=14; image[2064]=13; image[2065]=6; image[2066]=22; image[2067]=59; image[2068]=83; image[2069]=61; image[2070]=47; image[2071]=47; image[2072]=46; image[2073]=41; image[2074]=35; image[2075]=28; image[2076]=25; image[2077]=31; image[2078]=39; image[2079]=69; image[2080]=85; image[2081]=101; image[2082]=70; image[2083]=62; image[2084]=105; image[2085]=115; image[2086]=131; image[2087]=128; image[2088]=107; image[2089]=110; image[2090]=110; image[2091]=107; image[2092]=113; image[2093]=99; image[2094]=81; image[2095]=69; image[2096]=81; image[2097]=81; image[2098]=94; image[2099]=140; image[2100]=136; image[2101]=192; image[2102]=255; image[2103]=255; image[2104]=244; image[2105]=176; image[2106]=124; image[2107]=128; image[2108]=175; image[2109]=255; image[2110]=255; image[2111]=255; image[2112]=255; image[2113]=255; image[2114]=255; image[2115]=255; image[2116]=255; image[2117]=255; image[2118]=255; image[2119]=255; image[2120]=255; image[2121]=174; image[2122]=116; image[2123]=165; image[2124]=46; image[2125]=0; image[2126]=2; image[2127]=1; image[2128]=1; image[2129]=2; image[2130]=1; image[2131]=1; image[2132]=1; image[2133]=1; image[2134]=1; image[2135]=1; image[2136]=1; image[2137]=1; image[2138]=1; image[2139]=1; image[2140]=1; image[2141]=1; image[2142]=1; image[2143]=1; image[2144]=1; image[2145]=1; image[2146]=1; image[2147]=1; image[2148]=1; image[2149]=1; image[2150]=1; image[2151]=1; image[2152]=1; image[2153]=1; image[2154]=1; image[2155]=1; image[2156]=1; image[2157]=1; image[2158]=1; image[2159]=1; image[2160]=1; image[2161]=1; image[2162]=1; image[2163]=1; image[2164]=1; image[2165]=1; image[2166]=1; image[2167]=1; image[2168]=1; image[2169]=1; image[2170]=1; image[2171]=1; image[2172]=1; image[2173]=1; image[2174]=1; image[2175]=1; image[2176]=1; image[2177]=1; image[2178]=1; image[2179]=1; image[2180]=1; image[2181]=1; image[2182]=1; image[2183]=1; image[2184]=1; image[2185]=1; image[2186]=1; image[2187]=1; image[2188]=1; image[2189]=1; image[2190]=1; image[2191]=1; image[2192]=1; image[2193]=1; image[2194]=1; image[2195]=1; image[2196]=1; image[2197]=1; image[2198]=1; image[2199]=1; image[2200]=1; image[2201]=1; image[2202]=1; image[2203]=1; image[2204]=1; image[2205]=1; image[2206]=1; image[2207]=1; image[2208]=1; image[2209]=1; image[2210]=1; image[2211]=1; image[2212]=1; image[2213]=1; image[2214]=1; image[2215]=1; image[2216]=1; image[2217]=1; image[2218]=1; image[2219]=1; image[2220]=1; image[2221]=1; image[2222]=1; image[2223]=1; image[2224]=1; image[2225]=1; image[2226]=1; image[2227]=1; image[2228]=1; image[2229]=1; image[2230]=1; image[2231]=1; image[2232]=1; image[2233]=1; image[2234]=1; image[2235]=1; image[2236]=1; image[2237]=2; image[2238]=1; image[2239]=1; image[2240]=2; image[2241]=2; image[2242]=3; image[2243]=3; image[2244]=3; image[2245]=3; image[2246]=6; image[2247]=5; image[2248]=4; image[2249]=4; image[2250]=4; image[2251]=6; image[2252]=13; image[2253]=17; image[2254]=17; image[2255]=20; image[2256]=19; image[2257]=18; image[2258]=16; image[2259]=12; image[2260]=9; image[2261]=6; image[2262]=5; image[2263]=6; image[2264]=6; image[2265]=9; image[2266]=27; image[2267]=87; image[2268]=77; image[2269]=56; image[2270]=53; image[2271]=48; image[2272]=33; image[2273]=33; image[2274]=26; image[2275]=15; image[2276]=10; image[2277]=9; image[2278]=24; image[2279]=39; image[2280]=59; image[2281]=52; image[2282]=44; image[2283]=75; image[2284]=93; image[2285]=103; image[2286]=100; image[2287]=103; image[2288]=118; image[2289]=121; image[2290]=126; image[2291]=119; image[2292]=113; image[2293]=103; image[2294]=94; image[2295]=86; image[2296]=82; image[2297]=83; image[2298]=100; image[2299]=140; image[2300]=169; image[2301]=224; image[2302]=255; image[2303]=255; image[2304]=242; image[2305]=166; image[2306]=131; image[2307]=117; image[2308]=186; image[2309]=255; image[2310]=255; image[2311]=212; image[2312]=248; image[2313]=255; image[2314]=255; image[2315]=255; image[2316]=255; image[2317]=255; image[2318]=255; image[2319]=255; image[2320]=237; image[2321]=123; image[2322]=154; image[2323]=115; image[2324]=9; image[2325]=2; image[2326]=1; image[2327]=1; image[2328]=1; image[2329]=1; image[2330]=2; image[2331]=1; image[2332]=1; image[2333]=1; image[2334]=1; image[2335]=1; image[2336]=1; image[2337]=1; image[2338]=1; image[2339]=1; image[2340]=1; image[2341]=1; image[2342]=1; image[2343]=1; image[2344]=1; image[2345]=1; image[2346]=1; image[2347]=1; image[2348]=1; image[2349]=1; image[2350]=1; image[2351]=1; image[2352]=1; image[2353]=1; image[2354]=1; image[2355]=1; image[2356]=1; image[2357]=1; image[2358]=1; image[2359]=1; image[2360]=1; image[2361]=1; image[2362]=1; image[2363]=1; image[2364]=1; image[2365]=1; image[2366]=1; image[2367]=1; image[2368]=1; image[2369]=1; image[2370]=1; image[2371]=1; image[2372]=1; image[2373]=1; image[2374]=1; image[2375]=1; image[2376]=1; image[2377]=1; image[2378]=1; image[2379]=1; image[2380]=1; image[2381]=1; image[2382]=1; image[2383]=1; image[2384]=1; image[2385]=1; image[2386]=1; image[2387]=1; image[2388]=1; image[2389]=1; image[2390]=1; image[2391]=1; image[2392]=1; image[2393]=1; image[2394]=1; image[2395]=1; image[2396]=1; image[2397]=1; image[2398]=1; image[2399]=1; image[2400]=1; image[2401]=1; image[2402]=1; image[2403]=1; image[2404]=1; image[2405]=1; image[2406]=1; image[2407]=1; image[2408]=1; image[2409]=1; image[2410]=1; image[2411]=1; image[2412]=1; image[2413]=1; image[2414]=1; image[2415]=1; image[2416]=1; image[2417]=1; image[2418]=1; image[2419]=1; image[2420]=1; image[2421]=1; image[2422]=1; image[2423]=1; image[2424]=1; image[2425]=1; image[2426]=1; image[2427]=1; image[2428]=1; image[2429]=1; image[2430]=1; image[2431]=1; image[2432]=1; image[2433]=1; image[2434]=1; image[2435]=1; image[2436]=1; image[2437]=1; image[2438]=1; image[2439]=2; image[2440]=2; image[2441]=3; image[2442]=3; image[2443]=3; image[2444]=3; image[2445]=6; image[2446]=7; image[2447]=4; image[2448]=4; image[2449]=4; image[2450]=4; image[2451]=11; image[2452]=16; image[2453]=15; image[2454]=16; image[2455]=17; image[2456]=17; image[2457]=14; image[2458]=8; image[2459]=6; image[2460]=5; image[2461]=8; image[2462]=9; image[2463]=9; image[2464]=7; image[2465]=17; image[2466]=75; image[2467]=80; image[2468]=63; image[2469]=52; image[2470]=50; image[2471]=33; image[2472]=35; image[2473]=32; image[2474]=17; image[2475]=8; image[2476]=3; image[2477]=9; image[2478]=19; image[2479]=40; image[2480]=46; image[2481]=39; image[2482]=69; image[2483]=85; image[2484]=82; image[2485]=80; image[2486]=86; image[2487]=87; image[2488]=100; image[2489]=135; image[2490]=118; image[2491]=120; image[2492]=119; image[2493]=106; image[2494]=95; image[2495]=80; image[2496]=82; image[2497]=100; image[2498]=145; image[2499]=193; image[2500]=207; image[2501]=240; image[2502]=250; image[2503]=253; image[2504]=197; image[2505]=134; image[2506]=103; image[2507]=140; image[2508]=240; image[2509]=255; image[2510]=172; image[2511]=225; image[2512]=255; image[2513]=255; image[2514]=212; image[2515]=182; image[2516]=197; image[2517]=242; image[2518]=255; image[2519]=255; image[2520]=166; image[2521]=116; image[2522]=129; image[2523]=29; image[2524]=2; image[2525]=1; image[2526]=1; image[2527]=1; image[2528]=1; image[2529]=2; image[2530]=1; image[2531]=1; image[2532]=1; image[2533]=1; image[2534]=1; image[2535]=1; image[2536]=1; image[2537]=1; image[2538]=1; image[2539]=1; image[2540]=1; image[2541]=1; image[2542]=1; image[2543]=1; image[2544]=1; image[2545]=1; image[2546]=1; image[2547]=1; image[2548]=1; image[2549]=1; image[2550]=1; image[2551]=1; image[2552]=1; image[2553]=1; image[2554]=1; image[2555]=1; image[2556]=1; image[2557]=1; image[2558]=1; image[2559]=1; image[2560]=1; image[2561]=1; image[2562]=1; image[2563]=1; image[2564]=1; image[2565]=1; image[2566]=1; image[2567]=1; image[2568]=1; image[2569]=1; image[2570]=1; image[2571]=1; image[2572]=1; image[2573]=1; image[2574]=1; image[2575]=1; image[2576]=1; image[2577]=1; image[2578]=1; image[2579]=1; image[2580]=1; image[2581]=1; image[2582]=1; image[2583]=1; image[2584]=1; image[2585]=1; image[2586]=1; image[2587]=1; image[2588]=1; image[2589]=1; image[2590]=1; image[2591]=1; image[2592]=1; image[2593]=1; image[2594]=1; image[2595]=1; image[2596]=1; image[2597]=1; image[2598]=1; image[2599]=1; image[2600]=1; image[2601]=1; image[2602]=1; image[2603]=1; image[2604]=1; image[2605]=1; image[2606]=1; image[2607]=1; image[2608]=1; image[2609]=1; image[2610]=1; image[2611]=1; image[2612]=1; image[2613]=1; image[2614]=1; image[2615]=1; image[2616]=1; image[2617]=1; image[2618]=1; image[2619]=1; image[2620]=1; image[2621]=1; image[2622]=1; image[2623]=1; image[2624]=1; image[2625]=1; image[2626]=1; image[2627]=1; image[2628]=1; image[2629]=1; image[2630]=1; image[2631]=1; image[2632]=1; image[2633]=1; image[2634]=1; image[2635]=1; image[2636]=1; image[2637]=1; image[2638]=1; image[2639]=1; image[2640]=2; image[2641]=3; image[2642]=5; image[2643]=6; image[2644]=5; image[2645]=5; image[2646]=4; image[2647]=3; image[2648]=3; image[2649]=3; image[2650]=8; image[2651]=15; image[2652]=14; image[2653]=14; image[2654]=13; image[2655]=8; image[2656]=7; image[2657]=9; image[2658]=15; image[2659]=18; image[2660]=15; image[2661]=11; image[2662]=8; image[2663]=11; image[2664]=11; image[2665]=46; image[2666]=75; image[2667]=75; image[2668]=47; image[2669]=47; image[2670]=39; image[2671]=38; image[2672]=48; image[2673]=43; image[2674]=21; image[2675]=5; image[2676]=3; image[2677]=5; image[2678]=14; image[2679]=32; image[2680]=29; image[2681]=46; image[2682]=65; image[2683]=61; image[2684]=77; image[2685]=80; image[2686]=75; image[2687]=77; image[2688]=123; image[2689]=121; image[2690]=121; image[2691]=135; image[2692]=118; image[2693]=104; image[2694]=61; image[2695]=42; image[2696]=46; image[2697]=62; image[2698]=126; image[2699]=197; image[2700]=222; image[2701]=206; image[2702]=157; image[2703]=124; image[2704]=98; image[2705]=90; image[2706]=84; image[2707]=154; image[2708]=248; image[2709]=177; image[2710]=159; image[2711]=249; image[2712]=255; image[2713]=229; image[2714]=211; image[2715]=191; image[2716]=208; image[2717]=255; image[2718]=255; image[2719]=225; image[2720]=72; image[2721]=98; image[2722]=62; image[2723]=4; image[2724]=3; image[2725]=2; image[2726]=1; image[2727]=1; image[2728]=1; image[2729]=1; image[2730]=1; image[2731]=1; image[2732]=1; image[2733]=1; image[2734]=1; image[2735]=1; image[2736]=1; image[2737]=1; image[2738]=1; image[2739]=1; image[2740]=1; image[2741]=1; image[2742]=1; image[2743]=1; image[2744]=1; image[2745]=1; image[2746]=1; image[2747]=1; image[2748]=1; image[2749]=1; image[2750]=1; image[2751]=1; image[2752]=1; image[2753]=1; image[2754]=1; image[2755]=1; image[2756]=1; image[2757]=1; image[2758]=1; image[2759]=1; image[2760]=1; image[2761]=1; image[2762]=1; image[2763]=1; image[2764]=1; image[2765]=1; image[2766]=1; image[2767]=1; image[2768]=1; image[2769]=1; image[2770]=1; image[2771]=1; image[2772]=1; image[2773]=1; image[2774]=1; image[2775]=1; image[2776]=1; image[2777]=1; image[2778]=1; image[2779]=1; image[2780]=1; image[2781]=1; image[2782]=1; image[2783]=1; image[2784]=1; image[2785]=1; image[2786]=1; image[2787]=1; image[2788]=1; image[2789]=1; image[2790]=1; image[2791]=1; image[2792]=1; image[2793]=1; image[2794]=1; image[2795]=1; image[2796]=1; image[2797]=1; image[2798]=1; image[2799]=1; image[2800]=1; image[2801]=1; image[2802]=1; image[2803]=1; image[2804]=1; image[2805]=1; image[2806]=1; image[2807]=1; image[2808]=1; image[2809]=1; image[2810]=1; image[2811]=1; image[2812]=1; image[2813]=1; image[2814]=1; image[2815]=1; image[2816]=1; image[2817]=1; image[2818]=1; image[2819]=1; image[2820]=1; image[2821]=1; image[2822]=1; image[2823]=1; image[2824]=1; image[2825]=1; image[2826]=1; image[2827]=1; image[2828]=1; image[2829]=1; image[2830]=1; image[2831]=1; image[2832]=1; image[2833]=1; image[2834]=1; image[2835]=1; image[2836]=1; image[2837]=1; image[2838]=1; image[2839]=2; image[2840]=3; image[2841]=6; image[2842]=6; image[2843]=6; image[2844]=5; image[2845]=5; image[2846]=4; image[2847]=4; image[2848]=4; image[2849]=7; image[2850]=11; image[2851]=10; image[2852]=9; image[2853]=9; image[2854]=13; image[2855]=17; image[2856]=25; image[2857]=26; image[2858]=21; image[2859]=9; image[2860]=10; image[2861]=16; image[2862]=15; image[2863]=12; image[2864]=24; image[2865]=56; image[2866]=73; image[2867]=51; image[2868]=51; image[2869]=46; image[2870]=38; image[2871]=49; image[2872]=49; image[2873]=40; image[2874]=22; image[2875]=13; image[2876]=14; image[2877]=19; image[2878]=30; image[2879]=35; image[2880]=41; image[2881]=66; image[2882]=77; image[2883]=75; image[2884]=81; image[2885]=102; image[2886]=90; image[2887]=111; image[2888]=128; image[2889]=128; image[2890]=145; image[2891]=122; image[2892]=106; image[2893]=80; image[2894]=44; image[2895]=26; image[2896]=34; image[2897]=94; image[2898]=219; image[2899]=249; image[2900]=247; image[2901]=229; image[2902]=173; image[2903]=125; image[2904]=103; image[2905]=86; image[2906]=130; image[2907]=253; image[2908]=241; image[2909]=193; image[2910]=227; image[2911]=255; image[2912]=255; image[2913]=255; image[2914]=254; image[2915]=228; image[2916]=253; image[2917]=255; image[2918]=254; image[2919]=180; image[2920]=101; image[2921]=87; image[2922]=13; image[2923]=2; image[2924]=3; image[2925]=1; image[2926]=1; image[2927]=2; image[2928]=1; image[2929]=1; image[2930]=1; image[2931]=1; image[2932]=1; image[2933]=1; image[2934]=1; image[2935]=1; image[2936]=1; image[2937]=1; image[2938]=1; image[2939]=1; image[2940]=1; image[2941]=1; image[2942]=1; image[2943]=1; image[2944]=1; image[2945]=1; image[2946]=1; image[2947]=1; image[2948]=1; image[2949]=1; image[2950]=1; image[2951]=1; image[2952]=1; image[2953]=1; image[2954]=1; image[2955]=1; image[2956]=1; image[2957]=1; image[2958]=1; image[2959]=1; image[2960]=1; image[2961]=1; image[2962]=1; image[2963]=1; image[2964]=1; image[2965]=1; image[2966]=1; image[2967]=1; image[2968]=1; image[2969]=1; image[2970]=1; image[2971]=1; image[2972]=1; image[2973]=1; image[2974]=1; image[2975]=1; image[2976]=1; image[2977]=1; image[2978]=1; image[2979]=1; image[2980]=1; image[2981]=1; image[2982]=1; image[2983]=0; image[2984]=1; image[2985]=1; image[2986]=1; image[2987]=1; image[2988]=1; image[2989]=1; image[2990]=1; image[2991]=1; image[2992]=1; image[2993]=1; image[2994]=1; image[2995]=1; image[2996]=1; image[2997]=1; image[2998]=1; image[2999]=1; image[3000]=1; image[3001]=1; image[3002]=1; image[3003]=1; image[3004]=1; image[3005]=1; image[3006]=1; image[3007]=1; image[3008]=1; image[3009]=1; image[3010]=1; image[3011]=1; image[3012]=1; image[3013]=1; image[3014]=1; image[3015]=1; image[3016]=1; image[3017]=1; image[3018]=1; image[3019]=1; image[3020]=1; image[3021]=1; image[3022]=1; image[3023]=1; image[3024]=1; image[3025]=1; image[3026]=1; image[3027]=1; image[3028]=1; image[3029]=1; image[3030]=1; image[3031]=1; image[3032]=1; image[3033]=1; image[3034]=1; image[3035]=1; image[3036]=1; image[3037]=2; image[3038]=2; image[3039]=2; image[3040]=4; image[3041]=5; image[3042]=7; image[3043]=7; image[3044]=6; image[3045]=5; image[3046]=4; image[3047]=4; image[3048]=5; image[3049]=5; image[3050]=6; image[3051]=7; image[3052]=15; image[3053]=25; image[3054]=30; image[3055]=31; image[3056]=22; image[3057]=12; image[3058]=5; image[3059]=10; image[3060]=20; image[3061]=16; image[3062]=11; image[3063]=11; image[3064]=40; image[3065]=71; image[3066]=63; image[3067]=53; image[3068]=47; image[3069]=38; image[3070]=47; image[3071]=49; image[3072]=53; image[3073]=40; image[3074]=21; image[3075]=28; image[3076]=35; image[3077]=30; image[3078]=36; image[3079]=45; image[3080]=70; image[3081]=79; image[3082]=63; image[3083]=77; image[3084]=114; image[3085]=98; image[3086]=95; image[3087]=108; image[3088]=122; image[3089]=148; image[3090]=123; image[3091]=96; image[3092]=84; image[3093]=56; image[3094]=30; image[3095]=23; image[3096]=54; image[3097]=194; image[3098]=255; image[3099]=255; image[3100]=255; image[3101]=223; image[3102]=160; image[3103]=124; image[3104]=98; image[3105]=142; image[3106]=255; image[3107]=255; image[3108]=236; image[3109]=234; image[3110]=255; image[3111]=255; image[3112]=255; image[3113]=255; image[3114]=253; image[3115]=254; image[3116]=255; image[3117]=255; image[3118]=255; image[3119]=139; image[3120]=88; image[3121]=18; image[3122]=3; image[3123]=3; image[3124]=1; image[3125]=2; image[3126]=3; image[3127]=2; image[3128]=1; image[3129]=1; image[3130]=1; image[3131]=1; image[3132]=1; image[3133]=1; image[3134]=1; image[3135]=1; image[3136]=1; image[3137]=1; image[3138]=1; image[3139]=1; image[3140]=1; image[3141]=1; image[3142]=1; image[3143]=1; image[3144]=1; image[3145]=1; image[3146]=1; image[3147]=1; image[3148]=1; image[3149]=1; image[3150]=1; image[3151]=1; image[3152]=1; image[3153]=1; image[3154]=1; image[3155]=1; image[3156]=1; image[3157]=1; image[3158]=1; image[3159]=1; image[3160]=1; image[3161]=1; image[3162]=1; image[3163]=1; image[3164]=1; image[3165]=1; image[3166]=1; image[3167]=1; image[3168]=1; image[3169]=1; image[3170]=1; image[3171]=1; image[3172]=1; image[3173]=1; image[3174]=1; image[3175]=1; image[3176]=1; image[3177]=1; image[3178]=1; image[3179]=1; image[3180]=1; image[3181]=1; image[3182]=1; image[3183]=1; image[3184]=1; image[3185]=1; image[3186]=1; image[3187]=1; image[3188]=1; image[3189]=1; image[3190]=1; image[3191]=1; image[3192]=1; image[3193]=1; image[3194]=1; image[3195]=1; image[3196]=1; image[3197]=1; image[3198]=1; image[3199]=1; image[3200]=1; image[3201]=1; image[3202]=1; image[3203]=1; image[3204]=1; image[3205]=1; image[3206]=1; image[3207]=1; image[3208]=1; image[3209]=1; image[3210]=1; image[3211]=1; image[3212]=1; image[3213]=1; image[3214]=1; image[3215]=1; image[3216]=1; image[3217]=1; image[3218]=1; image[3219]=1; image[3220]=1; image[3221]=1; image[3222]=1; image[3223]=1; image[3224]=1; image[3225]=1; image[3226]=1; image[3227]=1; image[3228]=1; image[3229]=1; image[3230]=1; image[3231]=1; image[3232]=1; image[3233]=1; image[3234]=1; image[3235]=2; image[3236]=2; image[3237]=2; image[3238]=1; image[3239]=2; image[3240]=3; image[3241]=6; image[3242]=6; image[3243]=6; image[3244]=5; image[3245]=5; image[3246]=4; image[3247]=3; image[3248]=4; image[3249]=6; image[3250]=11; image[3251]=24; image[3252]=28; image[3253]=27; image[3254]=14; image[3255]=7; image[3256]=10; image[3257]=18; image[3258]=18; image[3259]=23; image[3260]=24; image[3261]=20; image[3262]=11; image[3263]=28; image[3264]=59; image[3265]=75; image[3266]=53; image[3267]=40; image[3268]=43; image[3269]=49; image[3270]=55; image[3271]=61; image[3272]=58; image[3273]=19; image[3274]=22; image[3275]=39; image[3276]=38; image[3277]=36; image[3278]=36; image[3279]=49; image[3280]=62; image[3281]=53; image[3282]=64; image[3283]=93; image[3284]=109; image[3285]=95; image[3286]=81; image[3287]=92; image[3288]=128; image[3289]=136; image[3290]=105; image[3291]=85; image[3292]=64; image[3293]=47; image[3294]=39; image[3295]=45; image[3296]=49; image[3297]=146; image[3298]=255; image[3299]=255; image[3300]=252; image[3301]=174; image[3302]=105; image[3303]=90; image[3304]=109; image[3305]=190; image[3306]=255; image[3307]=255; image[3308]=255; image[3309]=255; image[3310]=255; image[3311]=255; image[3312]=255; image[3313]=255; image[3314]=255; image[3315]=255; image[3316]=255; image[3317]=255; image[3318]=234; image[3319]=105; image[3320]=60; image[3321]=10; image[3322]=2; image[3323]=2; image[3324]=1; image[3325]=1; image[3326]=1; image[3327]=2; image[3328]=1; image[3329]=1; image[3330]=1; image[3331]=1; image[3332]=1; image[3333]=1; image[3334]=1; image[3335]=1; image[3336]=1; image[3337]=1; image[3338]=1; image[3339]=1; image[3340]=1; image[3341]=1; image[3342]=1; image[3343]=1; image[3344]=1; image[3345]=1; image[3346]=1; image[3347]=1; image[3348]=1; image[3349]=1; image[3350]=1; image[3351]=1; image[3352]=1; image[3353]=1; image[3354]=1; image[3355]=1; image[3356]=1; image[3357]=1; image[3358]=1; image[3359]=1; image[3360]=1; image[3361]=1; image[3362]=1; image[3363]=1; image[3364]=1; image[3365]=1; image[3366]=1; image[3367]=1; image[3368]=1; image[3369]=1; image[3370]=1; image[3371]=1; image[3372]=1; image[3373]=1; image[3374]=1; image[3375]=1; image[3376]=1; image[3377]=1; image[3378]=1; image[3379]=1; image[3380]=1; image[3381]=1; image[3382]=1; image[3383]=1; image[3384]=1; image[3385]=1; image[3386]=1; image[3387]=1; image[3388]=1; image[3389]=1; image[3390]=1; image[3391]=1; image[3392]=1; image[3393]=1; image[3394]=1; image[3395]=1; image[3396]=1; image[3397]=1; image[3398]=1; image[3399]=1; image[3400]=1; image[3401]=1; image[3402]=1; image[3403]=1; image[3404]=1; image[3405]=1; image[3406]=1; image[3407]=1; image[3408]=1; image[3409]=1; image[3410]=1; image[3411]=1; image[3412]=1; image[3413]=1; image[3414]=1; image[3415]=1; image[3416]=1; image[3417]=1; image[3418]=1; image[3419]=1; image[3420]=1; image[3421]=1; image[3422]=1; image[3423]=1; image[3424]=1; image[3425]=1; image[3426]=1; image[3427]=1; image[3428]=1; image[3429]=1; image[3430]=1; image[3431]=1; image[3432]=1; image[3433]=1; image[3434]=1; image[3435]=2; image[3436]=2; image[3437]=1; image[3438]=1; image[3439]=2; image[3440]=6; image[3441]=7; image[3442]=6; image[3443]=4; image[3444]=4; image[3445]=5; image[3446]=3; image[3447]=3; image[3448]=6; image[3449]=11; image[3450]=18; image[3451]=18; image[3452]=16; image[3453]=12; image[3454]=17; image[3455]=24; image[3456]=31; image[3457]=28; image[3458]=27; image[3459]=29; image[3460]=28; image[3461]=14; image[3462]=24; image[3463]=48; image[3464]=65; image[3465]=54; image[3466]=41; image[3467]=43; image[3468]=49; image[3469]=53; image[3470]=58; image[3471]=67; image[3472]=30; image[3473]=17; image[3474]=23; image[3475]=40; image[3476]=43; image[3477]=34; image[3478]=40; image[3479]=54; image[3480]=60; image[3481]=63; image[3482]=68; image[3483]=89; image[3484]=87; image[3485]=79; image[3486]=85; image[3487]=124; image[3488]=151; image[3489]=119; image[3490]=98; image[3491]=74; image[3492]=52; image[3493]=44; image[3494]=61; image[3495]=72; image[3496]=99; image[3497]=233; image[3498]=255; image[3499]=255; image[3500]=227; image[3501]=110; image[3502]=74; image[3503]=78; image[3504]=139; image[3505]=255; image[3506]=255; image[3507]=255; image[3508]=255; image[3509]=255; image[3510]=255; image[3511]=252; image[3512]=254; image[3513]=255; image[3514]=255; image[3515]=255; image[3516]=255; image[3517]=247; image[3518]=150; image[3519]=73; image[3520]=21; image[3521]=2; image[3522]=2; image[3523]=1; image[3524]=1; image[3525]=1; image[3526]=3; image[3527]=1; image[3528]=1; image[3529]=1; image[3530]=1; image[3531]=1; image[3532]=1; image[3533]=1; image[3534]=1; image[3535]=1; image[3536]=1; image[3537]=1; image[3538]=1; image[3539]=1; image[3540]=1; image[3541]=1; image[3542]=1; image[3543]=1; image[3544]=1; image[3545]=1; image[3546]=1; image[3547]=1; image[3548]=1; image[3549]=1; image[3550]=1; image[3551]=1; image[3552]=1; image[3553]=1; image[3554]=1; image[3555]=1; image[3556]=2; image[3557]=1; image[3558]=1; image[3559]=1; image[3560]=1; image[3561]=1; image[3562]=1; image[3563]=1; image[3564]=1; image[3565]=1; image[3566]=1; image[3567]=1; image[3568]=1; image[3569]=1; image[3570]=1; image[3571]=1; image[3572]=1; image[3573]=1; image[3574]=1; image[3575]=1; image[3576]=1; image[3577]=1; image[3578]=1; image[3579]=1; image[3580]=1; image[3581]=1; image[3582]=1; image[3583]=1; image[3584]=1; image[3585]=1; image[3586]=1; image[3587]=1; image[3588]=1; image[3589]=1; image[3590]=1; image[3591]=1; image[3592]=1; image[3593]=1; image[3594]=1; image[3595]=1; image[3596]=1; image[3597]=1; image[3598]=1; image[3599]=1; image[3600]=1; image[3601]=1; image[3602]=1; image[3603]=1; image[3604]=1; image[3605]=1; image[3606]=1; image[3607]=1; image[3608]=1; image[3609]=1; image[3610]=1; image[3611]=1; image[3612]=1; image[3613]=1; image[3614]=1; image[3615]=1; image[3616]=1; image[3617]=1; image[3618]=1; image[3619]=1; image[3620]=1; image[3621]=1; image[3622]=1; image[3623]=1; image[3624]=1; image[3625]=1; image[3626]=1; image[3627]=1; image[3628]=1; image[3629]=1; image[3630]=1; image[3631]=1; image[3632]=1; image[3633]=1; image[3634]=1; image[3635]=1; image[3636]=1; image[3637]=2; image[3638]=2; image[3639]=3; image[3640]=6; image[3641]=6; image[3642]=5; image[3643]=4; image[3644]=5; image[3645]=4; image[3646]=3; image[3647]=3; image[3648]=4; image[3649]=5; image[3650]=8; image[3651]=12; image[3652]=21; image[3653]=30; image[3654]=31; image[3655]=30; image[3656]=32; image[3657]=27; image[3658]=28; image[3659]=32; image[3660]=23; image[3661]=24; image[3662]=47; image[3663]=54; image[3664]=56; image[3665]=53; image[3666]=47; image[3667]=51; image[3668]=51; image[3669]=52; image[3670]=77; image[3671]=61; image[3672]=25; image[3673]=7; image[3674]=32; image[3675]=47; image[3676]=41; image[3677]=30; image[3678]=33; image[3679]=59; image[3680]=69; image[3681]=70; image[3682]=88; image[3683]=93; image[3684]=90; image[3685]=92; image[3686]=124; image[3687]=165; image[3688]=134; image[3689]=123; image[3690]=102; image[3691]=76; image[3692]=54; image[3693]=60; image[3694]=122; image[3695]=141; image[3696]=156; image[3697]=244; image[3698]=255; image[3699]=255; image[3700]=170; image[3701]=77; image[3702]=75; image[3703]=112; image[3704]=255; image[3705]=255; image[3706]=255; image[3707]=255; image[3708]=254; image[3709]=234; image[3710]=227; image[3711]=248; image[3712]=249; image[3713]=255; image[3714]=255; image[3715]=255; image[3716]=255; image[3717]=223; image[3718]=84; image[3719]=51; image[3720]=6; image[3721]=2; image[3722]=1; image[3723]=1; image[3724]=1; image[3725]=0; image[3726]=1; image[3727]=2; image[3728]=1; image[3729]=1; image[3730]=1; image[3731]=1; image[3732]=1; image[3733]=1; image[3734]=1; image[3735]=1; image[3736]=1; image[3737]=1; image[3738]=1; image[3739]=1; image[3740]=1; image[3741]=1; image[3742]=1; image[3743]=1; image[3744]=1; image[3745]=1; image[3746]=1; image[3747]=1; image[3748]=1; image[3749]=1; image[3750]=1; image[3751]=1; image[3752]=1; image[3753]=1; image[3754]=1; image[3755]=1; image[3756]=1; image[3757]=1; image[3758]=1; image[3759]=1; image[3760]=1; image[3761]=1; image[3762]=1; image[3763]=1; image[3764]=1; image[3765]=1; image[3766]=1; image[3767]=1; image[3768]=1; image[3769]=1; image[3770]=1; image[3771]=1; image[3772]=1; image[3773]=1; image[3774]=1; image[3775]=1; image[3776]=1; image[3777]=1; image[3778]=1; image[3779]=1; image[3780]=1; image[3781]=1; image[3782]=1; image[3783]=1; image[3784]=1; image[3785]=1; image[3786]=1; image[3787]=1; image[3788]=1; image[3789]=1; image[3790]=1; image[3791]=1; image[3792]=1; image[3793]=1; image[3794]=1; image[3795]=1; image[3796]=1; image[3797]=1; image[3798]=1; image[3799]=1; image[3800]=1; image[3801]=1; image[3802]=1; image[3803]=1; image[3804]=1; image[3805]=1; image[3806]=1; image[3807]=1; image[3808]=1; image[3809]=1; image[3810]=1; image[3811]=1; image[3812]=1; image[3813]=1; image[3814]=1; image[3815]=1; image[3816]=1; image[3817]=1; image[3818]=1; image[3819]=1; image[3820]=1; image[3821]=1; image[3822]=1; image[3823]=1; image[3824]=1; image[3825]=1; image[3826]=1; image[3827]=1; image[3828]=1; image[3829]=1; image[3830]=1; image[3831]=1; image[3832]=1; image[3833]=1; image[3834]=1; image[3835]=1; image[3836]=2; image[3837]=2; image[3838]=2; image[3839]=4; image[3840]=6; image[3841]=6; image[3842]=5; image[3843]=5; image[3844]=5; image[3845]=3; image[3846]=4; image[3847]=7; image[3848]=13; image[3849]=22; image[3850]=24; image[3851]=27; image[3852]=27; image[3853]=28; image[3854]=34; image[3855]=35; image[3856]=33; image[3857]=26; image[3858]=27; image[3859]=32; image[3860]=25; image[3861]=43; image[3862]=70; image[3863]=60; image[3864]=57; image[3865]=50; image[3866]=52; image[3867]=51; image[3868]=48; image[3869]=64; image[3870]=85; image[3871]=56; image[3872]=10; image[3873]=19; image[3874]=34; image[3875]=44; image[3876]=35; image[3877]=30; image[3878]=43; image[3879]=55; image[3880]=79; image[3881]=101; image[3882]=126; image[3883]=144; image[3884]=140; image[3885]=171; image[3886]=238; image[3887]=241; image[3888]=245; image[3889]=201; image[3890]=114; image[3891]=89; image[3892]=88; image[3893]=110; image[3894]=118; image[3895]=115; image[3896]=160; image[3897]=229; image[3898]=255; image[3899]=214; image[3900]=123; image[3901]=116; image[3902]=113; image[3903]=177; image[3904]=239; image[3905]=255; image[3906]=255; image[3907]=255; image[3908]=238; image[3909]=236; image[3910]=254; image[3911]=248; image[3912]=245; image[3913]=254; image[3914]=255; image[3915]=255; image[3916]=255; image[3917]=152; image[3918]=62; image[3919]=22; image[3920]=3; image[3921]=2; image[3922]=1; image[3923]=1; image[3924]=1; image[3925]=1; image[3926]=1; image[3927]=1; image[3928]=1; image[3929]=1; image[3930]=1; image[3931]=1; image[3932]=1; image[3933]=1; image[3934]=1; image[3935]=1; image[3936]=1; image[3937]=1; image[3938]=1; image[3939]=1; image[3940]=1; image[3941]=1; image[3942]=1; image[3943]=1; image[3944]=1; image[3945]=1; image[3946]=2; image[3947]=1; image[3948]=1; image[3949]=1; image[3950]=1; image[3951]=1; image[3952]=1; image[3953]=1; image[3954]=1; image[3955]=1; image[3956]=1; image[3957]=1; image[3958]=1; image[3959]=1; image[3960]=1; image[3961]=1; image[3962]=1; image[3963]=1; image[3964]=1; image[3965]=1; image[3966]=1; image[3967]=1; image[3968]=1; image[3969]=1; image[3970]=1; image[3971]=1; image[3972]=1; image[3973]=1; image[3974]=1; image[3975]=1; image[3976]=1; image[3977]=1; image[3978]=1; image[3979]=1; image[3980]=1; image[3981]=1; image[3982]=1; image[3983]=1; image[3984]=1; image[3985]=1; image[3986]=1; image[3987]=1; image[3988]=1; image[3989]=1; image[3990]=1; image[3991]=1; image[3992]=1; image[3993]=1; image[3994]=1; image[3995]=1; image[3996]=1; image[3997]=1; image[3998]=1; image[3999]=1; image[4000]=1; image[4001]=1; image[4002]=1; image[4003]=1; image[4004]=1; image[4005]=1; image[4006]=1; image[4007]=1; image[4008]=1; image[4009]=1; image[4010]=1; image[4011]=1; image[4012]=1; image[4013]=1; image[4014]=1; image[4015]=1; image[4016]=1; image[4017]=1; image[4018]=1; image[4019]=1; image[4020]=1; image[4021]=1; image[4022]=1; image[4023]=1; image[4024]=1; image[4025]=1; image[4026]=1; image[4027]=1; image[4028]=1; image[4029]=1; image[4030]=1; image[4031]=1; image[4032]=1; image[4033]=1; image[4034]=1; image[4035]=2; image[4036]=2; image[4037]=1; image[4038]=3; image[4039]=7; image[4040]=6; image[4041]=5; image[4042]=4; image[4043]=6; image[4044]=4; image[4045]=6; image[4046]=12; image[4047]=22; image[4048]=27; image[4049]=26; image[4050]=26; image[4051]=26; image[4052]=29; image[4053]=35; image[4054]=34; image[4055]=35; image[4056]=29; image[4057]=26; image[4058]=34; image[4059]=28; image[4060]=43; image[4061]=85; image[4062]=65; image[4063]=53; image[4064]=54; image[4065]=54; image[4066]=49; image[4067]=47; image[4068]=59; image[4069]=92; image[4070]=75; image[4071]=19; image[4072]=15; image[4073]=26; image[4074]=45; image[4075]=43; image[4076]=34; image[4077]=50; image[4078]=76; image[4079]=118; image[4080]=139; image[4081]=162; image[4082]=171; image[4083]=155; image[4084]=179; image[4085]=224; image[4086]=241; image[4087]=255; image[4088]=228; image[4089]=142; image[4090]=101; image[4091]=95; image[4092]=91; image[4093]=98; image[4094]=125; image[4095]=129; image[4096]=172; image[4097]=253; image[4098]=220; image[4099]=121; image[4100]=136; image[4101]=134; image[4102]=148; image[4103]=178; image[4104]=247; image[4105]=255; image[4106]=255; image[4107]=255; image[4108]=255; image[4109]=255; image[4110]=254; image[4111]=229; image[4112]=238; image[4113]=255; image[4114]=255; image[4115]=255; image[4116]=221; image[4117]=86; image[4118]=28; image[4119]=6; image[4120]=1; image[4121]=1; image[4122]=1; image[4123]=1; image[4124]=1; image[4125]=1; image[4126]=1; image[4127]=1; image[4128]=1; image[4129]=1; image[4130]=1; image[4131]=1; image[4132]=1; image[4133]=1; image[4134]=1; image[4135]=1; image[4136]=1; image[4137]=1; image[4138]=1; image[4139]=1; image[4140]=1; image[4141]=1; image[4142]=1; image[4143]=1; image[4144]=1; image[4145]=2; image[4146]=1; image[4147]=1; image[4148]=1; image[4149]=1; image[4150]=1; image[4151]=1; image[4152]=1; image[4153]=1; image[4154]=1; image[4155]=1; image[4156]=1; image[4157]=1; image[4158]=1; image[4159]=1; image[4160]=1; image[4161]=1; image[4162]=1; image[4163]=1; image[4164]=1; image[4165]=1; image[4166]=1; image[4167]=1; image[4168]=1; image[4169]=1; image[4170]=1; image[4171]=1; image[4172]=1; image[4173]=1; image[4174]=1; image[4175]=1; image[4176]=1; image[4177]=1; image[4178]=1; image[4179]=1; image[4180]=1; image[4181]=1; image[4182]=1; image[4183]=1; image[4184]=1; image[4185]=1; image[4186]=1; image[4187]=1; image[4188]=1; image[4189]=1; image[4190]=1; image[4191]=1; image[4192]=1; image[4193]=1; image[4194]=1; image[4195]=1; image[4196]=1; image[4197]=1; image[4198]=1; image[4199]=1; image[4200]=1; image[4201]=1; image[4202]=1; image[4203]=1; image[4204]=1; image[4205]=1; image[4206]=1; image[4207]=1; image[4208]=1; image[4209]=1; image[4210]=1; image[4211]=1; image[4212]=1; image[4213]=1; image[4214]=1; image[4215]=1; image[4216]=1; image[4217]=1; image[4218]=1; image[4219]=1; image[4220]=1; image[4221]=1; image[4222]=1; image[4223]=1; image[4224]=1; image[4225]=1; image[4226]=1; image[4227]=1; image[4228]=1; image[4229]=1; image[4230]=1; image[4231]=1; image[4232]=1; image[4233]=1; image[4234]=1; image[4235]=2; image[4236]=2; image[4237]=2; image[4238]=4; image[4239]=8; image[4240]=7; image[4241]=5; image[4242]=5; image[4243]=5; image[4244]=5; image[4245]=10; image[4246]=19; image[4247]=25; image[4248]=28; image[4249]=22; image[4250]=23; image[4251]=24; image[4252]=27; image[4253]=32; image[4254]=37; image[4255]=32; image[4256]=27; image[4257]=34; image[4258]=33; image[4259]=32; image[4260]=87; image[4261]=78; image[4262]=52; image[4263]=58; image[4264]=52; image[4265]=48; image[4266]=41; image[4267]=51; image[4268]=94; image[4269]=102; image[4270]=48; image[4271]=17; image[4272]=15; image[4273]=32; image[4274]=49; image[4275]=63; image[4276]=123; image[4277]=168; image[4278]=164; image[4279]=149; image[4280]=159; image[4281]=155; image[4282]=181; image[4283]=180; image[4284]=134; image[4285]=177; image[4286]=240; image[4287]=255; image[4288]=234; image[4289]=125; image[4290]=139; image[4291]=141; image[4292]=157; image[4293]=184; image[4294]=131; image[4295]=103; image[4296]=196; image[4297]=223; image[4298]=146; image[4299]=131; image[4300]=131; image[4301]=235; image[4302]=255; image[4303]=255; image[4304]=255; image[4305]=255; image[4306]=255; image[4307]=255; image[4308]=255; image[4309]=255; image[4310]=255; image[4311]=250; image[4312]=255; image[4313]=255; image[4314]=255; image[4315]=255; image[4316]=195; image[4317]=58; image[4318]=13; image[4319]=4; image[4320]=3; image[4321]=0; image[4322]=0; image[4323]=1; image[4324]=1; image[4325]=1; image[4326]=1; image[4327]=1; image[4328]=1; image[4329]=1; image[4330]=1; image[4331]=1; image[4332]=1; image[4333]=1; image[4334]=1; image[4335]=1; image[4336]=1; image[4337]=1; image[4338]=1; image[4339]=1; image[4340]=1; image[4341]=1; image[4342]=1; image[4343]=1; image[4344]=1; image[4345]=1; image[4346]=1; image[4347]=1; image[4348]=1; image[4349]=1; image[4350]=1; image[4351]=1; image[4352]=1; image[4353]=1; image[4354]=1; image[4355]=1; image[4356]=1; image[4357]=1; image[4358]=1; image[4359]=1; image[4360]=1; image[4361]=1; image[4362]=1; image[4363]=1; image[4364]=1; image[4365]=1; image[4366]=1; image[4367]=1; image[4368]=1; image[4369]=1; image[4370]=1; image[4371]=1; image[4372]=1; image[4373]=1; image[4374]=1; image[4375]=1; image[4376]=1; image[4377]=1; image[4378]=1; image[4379]=1; image[4380]=1; image[4381]=1; image[4382]=1; image[4383]=1; image[4384]=1; image[4385]=1; image[4386]=1; image[4387]=1; image[4388]=1; image[4389]=1; image[4390]=1; image[4391]=1; image[4392]=1; image[4393]=1; image[4394]=1; image[4395]=1; image[4396]=1; image[4397]=1; image[4398]=1; image[4399]=1; image[4400]=1; image[4401]=1; image[4402]=1; image[4403]=1; image[4404]=1; image[4405]=1; image[4406]=1; image[4407]=1; image[4408]=1; image[4409]=1; image[4410]=1; image[4411]=1; image[4412]=1; image[4413]=1; image[4414]=1; image[4415]=1; image[4416]=1; image[4417]=1; image[4418]=1; image[4419]=1; image[4420]=1; image[4421]=1; image[4422]=1; image[4423]=1; image[4424]=1; image[4425]=1; image[4426]=1; image[4427]=1; image[4428]=1; image[4429]=1; image[4430]=1; image[4431]=1; image[4432]=1; image[4433]=1; image[4434]=1; image[4435]=2; image[4436]=2; image[4437]=2; image[4438]=6; image[4439]=8; image[4440]=7; image[4441]=6; image[4442]=5; image[4443]=6; image[4444]=8; image[4445]=17; image[4446]=24; image[4447]=25; image[4448]=21; image[4449]=23; image[4450]=22; image[4451]=25; image[4452]=29; image[4453]=32; image[4454]=31; image[4455]=30; image[4456]=32; image[4457]=34; image[4458]=30; image[4459]=69; image[4460]=85; image[4461]=60; image[4462]=61; image[4463]=53; image[4464]=47; image[4465]=42; image[4466]=48; image[4467]=79; image[4468]=99; image[4469]=91; image[4470]=36; image[4471]=22; image[4472]=38; image[4473]=67; image[4474]=87; image[4475]=81; image[4476]=99; image[4477]=107; image[4478]=122; image[4479]=148; image[4480]=132; image[4481]=186; image[4482]=198; image[4483]=141; image[4484]=162; image[4485]=214; image[4486]=252; image[4487]=251; image[4488]=195; image[4489]=207; image[4490]=210; image[4491]=229; image[4492]=189; image[4493]=139; image[4494]=134; image[4495]=163; image[4496]=200; image[4497]=143; image[4498]=126; image[4499]=196; image[4500]=255; image[4501]=255; image[4502]=255; image[4503]=255; image[4504]=255; image[4505]=255; image[4506]=252; image[4507]=238; image[4508]=255; image[4509]=255; image[4510]=255; image[4511]=255; image[4512]=247; image[4513]=255; image[4514]=255; image[4515]=248; image[4516]=160; image[4517]=85; image[4518]=30; image[4519]=10; image[4520]=7; image[4521]=7; image[4522]=3; image[4523]=1; image[4524]=1; image[4525]=1; image[4526]=1; image[4527]=1; image[4528]=1; image[4529]=1; image[4530]=1; image[4531]=1; image[4532]=1; image[4533]=1; image[4534]=1; image[4535]=1; image[4536]=1; image[4537]=1; image[4538]=1; image[4539]=1; image[4540]=1; image[4541]=1; image[4542]=1; image[4543]=1; image[4544]=1; image[4545]=1; image[4546]=1; image[4547]=1; image[4548]=1; image[4549]=1; image[4550]=1; image[4551]=1; image[4552]=1; image[4553]=1; image[4554]=1; image[4555]=1; image[4556]=1; image[4557]=1; image[4558]=1; image[4559]=1; image[4560]=1; image[4561]=1; image[4562]=1; image[4563]=1; image[4564]=1; image[4565]=1; image[4566]=1; image[4567]=1; image[4568]=1; image[4569]=1; image[4570]=1; image[4571]=1; image[4572]=1; image[4573]=1; image[4574]=1; image[4575]=1; image[4576]=1; image[4577]=1; image[4578]=1; image[4579]=1; image[4580]=1; image[4581]=1; image[4582]=1; image[4583]=1; image[4584]=1; image[4585]=1; image[4586]=1; image[4587]=1; image[4588]=1; image[4589]=1; image[4590]=1; image[4591]=1; image[4592]=1; image[4593]=1; image[4594]=1; image[4595]=1; image[4596]=1; image[4597]=1; image[4598]=1; image[4599]=1; image[4600]=1; image[4601]=1; image[4602]=1; image[4603]=1; image[4604]=1; image[4605]=1; image[4606]=1; image[4607]=1; image[4608]=1; image[4609]=1; image[4610]=1; image[4611]=1; image[4612]=1; image[4613]=1; image[4614]=1; image[4615]=1; image[4616]=1; image[4617]=1; image[4618]=1; image[4619]=1; image[4620]=1; image[4621]=1; image[4622]=1; image[4623]=1; image[4624]=1; image[4625]=1; image[4626]=1; image[4627]=1; image[4628]=1; image[4629]=1; image[4630]=1; image[4631]=1; image[4632]=1; image[4633]=1; image[4634]=2; image[4635]=2; image[4636]=2; image[4637]=6; image[4638]=8; image[4639]=10; image[4640]=8; image[4641]=7; image[4642]=6; image[4643]=7; image[4644]=16; image[4645]=23; image[4646]=25; image[4647]=23; image[4648]=24; image[4649]=24; image[4650]=27; image[4651]=28; image[4652]=33; image[4653]=35; image[4654]=31; image[4655]=29; image[4656]=35; image[4657]=32; image[4658]=41; image[4659]=77; image[4660]=69; image[4661]=59; image[4662]=53; image[4663]=42; image[4664]=43; image[4665]=44; image[4666]=62; image[4667]=94; image[4668]=130; image[4669]=60; image[4670]=34; image[4671]=45; image[4672]=86; image[4673]=133; image[4674]=110; image[4675]=98; image[4676]=94; image[4677]=115; image[4678]=141; image[4679]=124; image[4680]=171; image[4681]=178; image[4682]=153; image[4683]=154; image[4684]=187; image[4685]=251; image[4686]=234; image[4687]=215; image[4688]=212; image[4689]=197; image[4690]=220; image[4691]=172; image[4692]=147; image[4693]=202; image[4694]=225; image[4695]=230; image[4696]=199; image[4697]=209; image[4698]=254; image[4699]=255; image[4700]=255; image[4701]=255; image[4702]=255; image[4703]=255; image[4704]=255; image[4705]=239; image[4706]=231; image[4707]=255; image[4708]=255; image[4709]=255; image[4710]=255; image[4711]=248; image[4712]=255; image[4713]=255; image[4714]=255; image[4715]=251; image[4716]=237; image[4717]=169; image[4718]=132; image[4719]=125; image[4720]=80; image[4721]=36; image[4722]=7; image[4723]=0; image[4724]=0; image[4725]=1; image[4726]=1; image[4727]=1; image[4728]=1; image[4729]=1; image[4730]=1; image[4731]=1; image[4732]=1; image[4733]=1; image[4734]=1; image[4735]=1; image[4736]=1; image[4737]=1; image[4738]=1; image[4739]=1; image[4740]=1; image[4741]=1; image[4742]=1; image[4743]=1; image[4744]=1; image[4745]=1; image[4746]=1; image[4747]=1; image[4748]=1; image[4749]=1; image[4750]=1; image[4751]=1; image[4752]=1; image[4753]=1; image[4754]=1; image[4755]=1; image[4756]=1; image[4757]=1; image[4758]=1; image[4759]=1; image[4760]=1; image[4761]=1; image[4762]=1; image[4763]=1; image[4764]=1; image[4765]=1; image[4766]=1; image[4767]=1; image[4768]=1; image[4769]=1; image[4770]=1; image[4771]=1; image[4772]=1; image[4773]=1; image[4774]=1; image[4775]=1; image[4776]=1; image[4777]=1; image[4778]=1; image[4779]=1; image[4780]=1; image[4781]=1; image[4782]=1; image[4783]=1; image[4784]=1; image[4785]=1; image[4786]=1; image[4787]=1; image[4788]=1; image[4789]=1; image[4790]=1; image[4791]=1; image[4792]=1; image[4793]=1; image[4794]=1; image[4795]=1; image[4796]=1; image[4797]=1; image[4798]=1; image[4799]=1; image[4800]=1; image[4801]=1; image[4802]=1; image[4803]=1; image[4804]=1; image[4805]=1; image[4806]=1; image[4807]=1; image[4808]=1; image[4809]=1; image[4810]=1; image[4811]=1; image[4812]=1; image[4813]=1; image[4814]=1; image[4815]=0; image[4816]=1; image[4817]=1; image[4818]=1; image[4819]=1; image[4820]=1; image[4821]=1; image[4822]=1; image[4823]=1; image[4824]=1; image[4825]=1; image[4826]=1; image[4827]=1; image[4828]=1; image[4829]=1; image[4830]=1; image[4831]=1; image[4832]=1; image[4833]=1; image[4834]=2; image[4835]=2; image[4836]=3; image[4837]=5; image[4838]=10; image[4839]=10; image[4840]=9; image[4841]=7; image[4842]=6; image[4843]=9; image[4844]=20; image[4845]=26; image[4846]=28; image[4847]=27; image[4848]=25; image[4849]=27; image[4850]=28; image[4851]=30; image[4852]=35; image[4853]=32; image[4854]=30; image[4855]=29; image[4856]=29; image[4857]=19; image[4858]=42; image[4859]=84; image[4860]=72; image[4861]=67; image[4862]=38; image[4863]=40; image[4864]=38; image[4865]=47; image[4866]=69; image[4867]=119; image[4868]=88; image[4869]=60; image[4870]=34; image[4871]=83; image[4872]=154; image[4873]=197; image[4874]=203; image[4875]=170; image[4876]=119; image[4877]=103; image[4878]=78; image[4879]=104; image[4880]=114; image[4881]=117; image[4882]=115; image[4883]=167; image[4884]=248; image[4885]=251; image[4886]=212; image[4887]=238; image[4888]=254; image[4889]=255; image[4890]=254; image[4891]=250; image[4892]=255; image[4893]=255; image[4894]=255; image[4895]=255; image[4896]=255; image[4897]=255; image[4898]=255; image[4899]=255; image[4900]=255; image[4901]=255; image[4902]=255; image[4903]=255; image[4904]=255; image[4905]=255; image[4906]=255; image[4907]=255; image[4908]=255; image[4909]=255; image[4910]=255; image[4911]=255; image[4912]=255; image[4913]=255; image[4914]=255; image[4915]=255; image[4916]=255; image[4917]=255; image[4918]=255; image[4919]=255; image[4920]=248; image[4921]=145; image[4922]=53; image[4923]=14; image[4924]=1; image[4925]=1; image[4926]=1; image[4927]=1; image[4928]=1; image[4929]=1; image[4930]=1; image[4931]=1; image[4932]=1; image[4933]=1; image[4934]=1; image[4935]=1; image[4936]=1; image[4937]=1; image[4938]=1; image[4939]=1; image[4940]=1; image[4941]=1; image[4942]=1; image[4943]=1; image[4944]=1; image[4945]=1; image[4946]=1; image[4947]=1; image[4948]=1; image[4949]=1; image[4950]=1; image[4951]=1; image[4952]=1; image[4953]=1; image[4954]=1; image[4955]=1; image[4956]=1; image[4957]=1; image[4958]=1; image[4959]=1; image[4960]=1; image[4961]=1; image[4962]=1; image[4963]=1; image[4964]=1; image[4965]=1; image[4966]=1; image[4967]=1; image[4968]=1; image[4969]=1; image[4970]=1; image[4971]=1; image[4972]=1; image[4973]=1; image[4974]=1; image[4975]=1; image[4976]=1; image[4977]=1; image[4978]=1; image[4979]=1; image[4980]=1; image[4981]=1; image[4982]=1; image[4983]=1; image[4984]=1; image[4985]=1; image[4986]=1; image[4987]=1; image[4988]=1; image[4989]=1; image[4990]=1; image[4991]=1; image[4992]=1; image[4993]=1; image[4994]=1; image[4995]=1; image[4996]=1; image[4997]=1; image[4998]=1; image[4999]=1; image[5000]=1; image[5001]=1; image[5002]=1; image[5003]=0; image[5004]=1; image[5005]=1; image[5006]=1; image[5007]=1; image[5008]=1; image[5009]=1; image[5010]=1; image[5011]=1; image[5012]=1; image[5013]=1; image[5014]=1; image[5015]=1; image[5016]=1; image[5017]=1; image[5018]=1; image[5019]=1; image[5020]=1; image[5021]=1; image[5022]=1; image[5023]=1; image[5024]=1; image[5025]=1; image[5026]=0; image[5027]=1; image[5028]=1; image[5029]=1; image[5030]=1; image[5031]=1; image[5032]=1; image[5033]=1; image[5034]=3; image[5035]=2; image[5036]=3; image[5037]=10; image[5038]=10; image[5039]=9; image[5040]=6; image[5041]=6; image[5042]=6; image[5043]=17; image[5044]=25; image[5045]=26; image[5046]=27; image[5047]=27; image[5048]=28; image[5049]=28; image[5050]=27; image[5051]=29; image[5052]=29; image[5053]=27; image[5054]=25; image[5055]=28; image[5056]=20; image[5057]=28; image[5058]=66; image[5059]=75; image[5060]=76; image[5061]=44; image[5062]=43; image[5063]=43; image[5064]=48; image[5065]=59; image[5066]=98; image[5067]=106; image[5068]=80; image[5069]=32; image[5070]=64; image[5071]=126; image[5072]=164; image[5073]=168; image[5074]=161; image[5075]=110; image[5076]=106; image[5077]=106; image[5078]=123; image[5079]=125; image[5080]=113; image[5081]=101; image[5082]=124; image[5083]=207; image[5084]=244; image[5085]=228; image[5086]=226; image[5087]=227; image[5088]=242; image[5089]=253; image[5090]=246; image[5091]=250; image[5092]=255; image[5093]=255; image[5094]=255; image[5095]=255; image[5096]=249; image[5097]=255; image[5098]=255; image[5099]=255; image[5100]=255; image[5101]=255; image[5102]=255; image[5103]=255; image[5104]=255; image[5105]=255; image[5106]=255; image[5107]=255; image[5108]=255; image[5109]=255; image[5110]=255; image[5111]=255; image[5112]=248; image[5113]=255; image[5114]=255; image[5115]=255; image[5116]=255; image[5117]=255; image[5118]=255; image[5119]=255; image[5120]=229; image[5121]=172; image[5122]=109; image[5123]=35; image[5124]=4; image[5125]=2; image[5126]=1; image[5127]=1; image[5128]=1; image[5129]=1; image[5130]=1; image[5131]=1; image[5132]=1; image[5133]=1; image[5134]=1; image[5135]=1; image[5136]=1; image[5137]=1; image[5138]=1; image[5139]=1; image[5140]=1; image[5141]=1; image[5142]=1; image[5143]=1; image[5144]=1; image[5145]=1; image[5146]=1; image[5147]=1; image[5148]=1; image[5149]=1; image[5150]=1; image[5151]=1; image[5152]=1; image[5153]=1; image[5154]=1; image[5155]=1; image[5156]=1; image[5157]=1; image[5158]=1; image[5159]=1; image[5160]=1; image[5161]=1; image[5162]=1; image[5163]=1; image[5164]=1; image[5165]=1; image[5166]=1; image[5167]=1; image[5168]=1; image[5169]=1; image[5170]=1; image[5171]=1; image[5172]=1; image[5173]=1; image[5174]=1; image[5175]=1; image[5176]=1; image[5177]=1; image[5178]=1; image[5179]=1; image[5180]=1; image[5181]=1; image[5182]=1; image[5183]=1; image[5184]=1; image[5185]=1; image[5186]=1; image[5187]=1; image[5188]=1; image[5189]=1; image[5190]=1; image[5191]=1; image[5192]=1; image[5193]=1; image[5194]=1; image[5195]=1; image[5196]=1; image[5197]=1; image[5198]=1; image[5199]=1; image[5200]=1; image[5201]=1; image[5202]=1; image[5203]=1; image[5204]=1; image[5205]=1; image[5206]=1; image[5207]=1; image[5208]=1; image[5209]=1; image[5210]=1; image[5211]=1; image[5212]=1; image[5213]=1; image[5214]=1; image[5215]=1; image[5216]=1; image[5217]=1; image[5218]=1; image[5219]=1; image[5220]=1; image[5221]=1; image[5222]=1; image[5223]=1; image[5224]=1; image[5225]=1; image[5226]=1; image[5227]=1; image[5228]=1; image[5229]=1; image[5230]=1; image[5231]=1; image[5232]=1; image[5233]=3; image[5234]=3; image[5235]=3; image[5236]=7; image[5237]=11; image[5238]=12; image[5239]=9; image[5240]=7; image[5241]=5; image[5242]=15; image[5243]=23; image[5244]=22; image[5245]=24; image[5246]=29; image[5247]=30; image[5248]=29; image[5249]=26; image[5250]=24; image[5251]=24; image[5252]=25; image[5253]=21; image[5254]=23; image[5255]=27; image[5256]=20; image[5257]=37; image[5258]=74; image[5259]=82; image[5260]=48; image[5261]=39; image[5262]=41; image[5263]=49; image[5264]=49; image[5265]=61; image[5266]=96; image[5267]=81; image[5268]=37; image[5269]=43; image[5270]=96; image[5271]=162; image[5272]=132; image[5273]=113; image[5274]=119; image[5275]=159; image[5276]=180; image[5277]=210; image[5278]=229; image[5279]=194; image[5280]=151; image[5281]=187; image[5282]=247; image[5283]=255; image[5284]=246; image[5285]=208; image[5286]=195; image[5287]=229; image[5288]=249; image[5289]=219; image[5290]=235; image[5291]=255; image[5292]=255; image[5293]=255; image[5294]=255; image[5295]=249; image[5296]=255; image[5297]=255; image[5298]=255; image[5299]=255; image[5300]=255; image[5301]=255; image[5302]=255; image[5303]=255; image[5304]=255; image[5305]=255; image[5306]=255; image[5307]=255; image[5308]=255; image[5309]=255; image[5310]=255; image[5311]=249; image[5312]=254; image[5313]=255; image[5314]=255; image[5315]=255; image[5316]=255; image[5317]=255; image[5318]=255; image[5319]=255; image[5320]=255; image[5321]=254; image[5322]=175; image[5323]=18; image[5324]=1; image[5325]=1; image[5326]=1; image[5327]=1; image[5328]=1; image[5329]=1; image[5330]=1; image[5331]=1; image[5332]=1; image[5333]=1; image[5334]=1; image[5335]=1; image[5336]=1; image[5337]=1; image[5338]=1; image[5339]=1; image[5340]=1; image[5341]=1; image[5342]=1; image[5343]=1; image[5344]=1; image[5345]=1; image[5346]=1; image[5347]=1; image[5348]=1; image[5349]=1; image[5350]=1; image[5351]=1; image[5352]=1; image[5353]=1; image[5354]=1; image[5355]=1; image[5356]=1; image[5357]=1; image[5358]=1; image[5359]=1; image[5360]=1; image[5361]=1; image[5362]=1; image[5363]=1; image[5364]=1; image[5365]=1; image[5366]=1; image[5367]=1; image[5368]=1; image[5369]=1; image[5370]=1; image[5371]=1; image[5372]=1; image[5373]=1; image[5374]=1; image[5375]=1; image[5376]=1; image[5377]=1; image[5378]=1; image[5379]=1; image[5380]=1; image[5381]=1; image[5382]=1; image[5383]=1; image[5384]=1; image[5385]=1; image[5386]=1; image[5387]=1; image[5388]=1; image[5389]=1; image[5390]=1; image[5391]=1; image[5392]=1; image[5393]=1; image[5394]=1; image[5395]=1; image[5396]=1; image[5397]=1; image[5398]=1; image[5399]=1; image[5400]=1; image[5401]=1; image[5402]=1; image[5403]=1; image[5404]=1; image[5405]=1; image[5406]=1; image[5407]=1; image[5408]=1; image[5409]=1; image[5410]=1; image[5411]=1; image[5412]=1; image[5413]=1; image[5414]=1; image[5415]=1; image[5416]=1; image[5417]=1; image[5418]=1; image[5419]=1; image[5420]=1; image[5421]=1; image[5422]=1; image[5423]=1; image[5424]=1; image[5425]=1; image[5426]=1; image[5427]=1; image[5428]=1; image[5429]=1; image[5430]=1; image[5431]=1; image[5432]=2; image[5433]=4; image[5434]=4; image[5435]=4; image[5436]=9; image[5437]=14; image[5438]=12; image[5439]=8; image[5440]=4; image[5441]=14; image[5442]=25; image[5443]=31; image[5444]=27; image[5445]=26; image[5446]=26; image[5447]=24; image[5448]=21; image[5449]=20; image[5450]=22; image[5451]=24; image[5452]=21; image[5453]=19; image[5454]=13; image[5455]=9; image[5456]=14; image[5457]=58; image[5458]=70; image[5459]=51; image[5460]=42; image[5461]=44; image[5462]=46; image[5463]=45; image[5464]=52; image[5465]=94; image[5466]=96; image[5467]=53; image[5468]=28; image[5469]=24; image[5470]=61; image[5471]=72; image[5472]=74; image[5473]=85; image[5474]=108; image[5475]=118; image[5476]=139; image[5477]=136; image[5478]=134; image[5479]=137; image[5480]=130; image[5481]=190; image[5482]=231; image[5483]=252; image[5484]=255; image[5485]=251; image[5486]=254; image[5487]=255; image[5488]=251; image[5489]=252; image[5490]=255; image[5491]=255; image[5492]=254; image[5493]=198; image[5494]=200; image[5495]=221; image[5496]=224; image[5497]=244; image[5498]=255; image[5499]=255; image[5500]=255; image[5501]=255; image[5502]=246; image[5503]=255; image[5504]=255; image[5505]=255; image[5506]=255; image[5507]=255; image[5508]=255; image[5509]=255; image[5510]=255; image[5511]=255; image[5512]=255; image[5513]=255; image[5514]=232; image[5515]=242; image[5516]=255; image[5517]=255; image[5518]=255; image[5519]=255; image[5520]=236; image[5521]=192; image[5522]=156; image[5523]=25; image[5524]=2; image[5525]=2; image[5526]=1; image[5527]=1; image[5528]=1; image[5529]=1; image[5530]=1; image[5531]=1; image[5532]=1; image[5533]=1; image[5534]=1; image[5535]=1; image[5536]=1; image[5537]=1; image[5538]=1; image[5539]=1; image[5540]=1; image[5541]=1; image[5542]=1; image[5543]=1; image[5544]=1; image[5545]=1; image[5546]=1; image[5547]=1; image[5548]=1; image[5549]=1; image[5550]=1; image[5551]=1; image[5552]=1; image[5553]=1; image[5554]=1; image[5555]=1; image[5556]=1; image[5557]=1; image[5558]=1; image[5559]=1; image[5560]=1; image[5561]=1; image[5562]=1; image[5563]=1; image[5564]=1; image[5565]=1; image[5566]=1; image[5567]=1; image[5568]=1; image[5569]=1; image[5570]=1; image[5571]=1; image[5572]=1; image[5573]=1; image[5574]=1; image[5575]=1; image[5576]=1; image[5577]=1; image[5578]=1; image[5579]=1; image[5580]=1; image[5581]=1; image[5582]=1; image[5583]=1; image[5584]=1; image[5585]=1; image[5586]=1; image[5587]=1; image[5588]=1; image[5589]=1; image[5590]=1; image[5591]=1; image[5592]=1; image[5593]=1; image[5594]=1; image[5595]=1; image[5596]=1; image[5597]=1; image[5598]=1; image[5599]=1; image[5600]=1; image[5601]=1; image[5602]=1; image[5603]=1; image[5604]=1; image[5605]=1; image[5606]=1; image[5607]=1; image[5608]=1; image[5609]=1; image[5610]=1; image[5611]=1; image[5612]=1; image[5613]=1; image[5614]=1; image[5615]=1; image[5616]=1; image[5617]=1; image[5618]=1; image[5619]=1; image[5620]=1; image[5621]=1; image[5622]=1; image[5623]=1; image[5624]=1; image[5625]=1; image[5626]=1; image[5627]=1; image[5628]=1; image[5629]=1; image[5630]=1; image[5631]=1; image[5632]=4; image[5633]=4; image[5634]=4; image[5635]=7; image[5636]=13; image[5637]=11; image[5638]=8; image[5639]=4; image[5640]=13; image[5641]=23; image[5642]=27; image[5643]=26; image[5644]=26; image[5645]=26; image[5646]=23; image[5647]=20; image[5648]=17; image[5649]=18; image[5650]=17; image[5651]=15; image[5652]=11; image[5653]=5; image[5654]=6; image[5655]=8; image[5656]=46; image[5657]=64; image[5658]=56; image[5659]=45; image[5660]=43; image[5661]=43; image[5662]=41; image[5663]=44; image[5664]=86; image[5665]=103; image[5666]=62; image[5667]=28; image[5668]=9; image[5669]=11; image[5670]=15; image[5671]=21; image[5672]=39; image[5673]=63; image[5674]=80; image[5675]=98; image[5676]=105; image[5677]=125; image[5678]=151; image[5679]=112; image[5680]=126; image[5681]=177; image[5682]=211; image[5683]=227; image[5684]=250; image[5685]=255; image[5686]=255; image[5687]=255; image[5688]=253; image[5689]=253; image[5690]=252; image[5691]=243; image[5692]=166; image[5693]=152; image[5694]=166; image[5695]=163; image[5696]=210; image[5697]=254; image[5698]=255; image[5699]=255; image[5700]=247; image[5701]=239; image[5702]=255; image[5703]=255; image[5704]=255; image[5705]=255; image[5706]=255; image[5707]=255; image[5708]=255; image[5709]=255; image[5710]=255; image[5711]=255; image[5712]=255; image[5713]=255; image[5714]=255; image[5715]=255; image[5716]=255; image[5717]=255; image[5718]=255; image[5719]=255; image[5720]=176; image[5721]=145; image[5722]=35; image[5723]=4; image[5724]=2; image[5725]=1; image[5726]=1; image[5727]=1; image[5728]=1; image[5729]=1; image[5730]=1; image[5731]=1; image[5732]=1; image[5733]=1; image[5734]=1; image[5735]=1; image[5736]=1; image[5737]=1; image[5738]=1; image[5739]=1; image[5740]=1; image[5741]=1; image[5742]=1; image[5743]=1; image[5744]=1; image[5745]=1; image[5746]=1; image[5747]=1; image[5748]=1; image[5749]=1; image[5750]=1; image[5751]=1; image[5752]=1; image[5753]=1; image[5754]=1; image[5755]=1; image[5756]=1; image[5757]=1; image[5758]=1; image[5759]=1; image[5760]=1; image[5761]=1; image[5762]=1; image[5763]=1; image[5764]=1; image[5765]=1; image[5766]=1; image[5767]=1; image[5768]=1; image[5769]=1; image[5770]=1; image[5771]=1; image[5772]=1; image[5773]=1; image[5774]=1; image[5775]=1; image[5776]=1; image[5777]=1; image[5778]=1; image[5779]=1; image[5780]=1; image[5781]=1; image[5782]=1; image[5783]=1; image[5784]=1; image[5785]=1; image[5786]=1; image[5787]=1; image[5788]=1; image[5789]=1; image[5790]=1; image[5791]=1; image[5792]=1; image[5793]=1; image[5794]=1; image[5795]=1; image[5796]=1; image[5797]=1; image[5798]=1; image[5799]=1; image[5800]=1; image[5801]=1; image[5802]=1; image[5803]=1; image[5804]=1; image[5805]=1; image[5806]=1; image[5807]=1; image[5808]=1; image[5809]=1; image[5810]=1; image[5811]=1; image[5812]=1; image[5813]=1; image[5814]=1; image[5815]=1; image[5816]=1; image[5817]=2; image[5818]=2; image[5819]=2; image[5820]=1; image[5821]=1; image[5822]=1; image[5823]=1; image[5824]=1; image[5825]=1; image[5826]=1; image[5827]=1; image[5828]=1; image[5829]=1; image[5830]=1; image[5831]=2; image[5832]=3; image[5833]=3; image[5834]=4; image[5835]=8; image[5836]=14; image[5837]=10; image[5838]=5; image[5839]=8; image[5840]=14; image[5841]=18; image[5842]=18; image[5843]=17; image[5844]=18; image[5845]=15; image[5846]=11; image[5847]=7; image[5848]=6; image[5849]=10; image[5850]=9; image[5851]=10; image[5852]=10; image[5853]=11; image[5854]=6; image[5855]=35; image[5856]=65; image[5857]=67; image[5858]=53; image[5859]=43; image[5860]=43; image[5861]=41; image[5862]=42; image[5863]=68; image[5864]=110; image[5865]=105; image[5866]=51; image[5867]=11; image[5868]=3; image[5869]=3; image[5870]=1; image[5871]=10; image[5872]=30; image[5873]=55; image[5874]=82; image[5875]=119; image[5876]=140; image[5877]=179; image[5878]=192; image[5879]=142; image[5880]=152; image[5881]=203; image[5882]=243; image[5883]=255; image[5884]=255; image[5885]=255; image[5886]=239; image[5887]=164; image[5888]=147; image[5889]=98; image[5890]=84; image[5891]=91; image[5892]=117; image[5893]=124; image[5894]=124; image[5895]=165; image[5896]=214; image[5897]=255; image[5898]=255; image[5899]=255; image[5900]=255; image[5901]=255; image[5902]=255; image[5903]=255; image[5904]=255; image[5905]=255; image[5906]=255; image[5907]=255; image[5908]=255; image[5909]=255; image[5910]=255; image[5911]=255; image[5912]=255; image[5913]=255; image[5914]=255; image[5915]=255; image[5916]=255; image[5917]=255; image[5918]=255; image[5919]=255; image[5920]=127; image[5921]=87; image[5922]=42; image[5923]=2; image[5924]=1; image[5925]=1; image[5926]=1; image[5927]=1; image[5928]=1; image[5929]=1; image[5930]=1; image[5931]=1; image[5932]=1; image[5933]=1; image[5934]=1; image[5935]=1; image[5936]=1; image[5937]=1; image[5938]=1; image[5939]=1; image[5940]=1; image[5941]=1; image[5942]=1; image[5943]=1; image[5944]=1; image[5945]=1; image[5946]=1; image[5947]=1; image[5948]=1; image[5949]=1; image[5950]=1; image[5951]=1; image[5952]=1; image[5953]=1; image[5954]=1; image[5955]=1; image[5956]=1; image[5957]=1; image[5958]=1; image[5959]=1; image[5960]=1; image[5961]=1; image[5962]=1; image[5963]=1; image[5964]=1; image[5965]=1; image[5966]=1; image[5967]=1; image[5968]=1; image[5969]=1; image[5970]=1; image[5971]=1; image[5972]=1; image[5973]=1; image[5974]=1; image[5975]=1; image[5976]=1; image[5977]=1; image[5978]=1; image[5979]=1; image[5980]=1; image[5981]=1; image[5982]=1; image[5983]=1; image[5984]=1; image[5985]=1; image[5986]=1; image[5987]=1; image[5988]=1; image[5989]=1; image[5990]=1; image[5991]=1; image[5992]=1; image[5993]=1; image[5994]=1; image[5995]=1; image[5996]=1; image[5997]=1; image[5998]=1; image[5999]=1; image[6000]=1; image[6001]=1; image[6002]=1; image[6003]=1; image[6004]=1; image[6005]=1; image[6006]=1; image[6007]=1; image[6008]=1; image[6009]=1; image[6010]=1; image[6011]=1; image[6012]=1; image[6013]=1; image[6014]=1; image[6015]=1; image[6016]=2; image[6017]=2; image[6018]=2; image[6019]=1; image[6020]=1; image[6021]=1; image[6022]=1; image[6023]=1; image[6024]=1; image[6025]=1; image[6026]=1; image[6027]=1; image[6028]=1; image[6029]=1; image[6030]=1; image[6031]=3; image[6032]=5; image[6033]=5; image[6034]=7; image[6035]=13; image[6036]=12; image[6037]=6; image[6038]=6; image[6039]=12; image[6040]=17; image[6041]=14; image[6042]=11; image[6043]=10; image[6044]=10; image[6045]=11; image[6046]=19; image[6047]=22; image[6048]=29; image[6049]=26; image[6050]=19; image[6051]=11; image[6052]=9; image[6053]=9; image[6054]=28; image[6055]=59; image[6056]=62; image[6057]=48; image[6058]=42; image[6059]=44; image[6060]=44; image[6061]=52; image[6062]=56; image[6063]=87; image[6064]=138; image[6065]=90; image[6066]=34; image[6067]=10; image[6068]=15; image[6069]=27; image[6070]=25; image[6071]=33; image[6072]=49; image[6073]=79; image[6074]=108; image[6075]=127; image[6076]=160; image[6077]=174; image[6078]=140; image[6079]=166; image[6080]=190; image[6081]=195; image[6082]=205; image[6083]=214; image[6084]=227; image[6085]=231; image[6086]=154; image[6087]=73; image[6088]=65; image[6089]=64; image[6090]=65; image[6091]=73; image[6092]=64; image[6093]=71; image[6094]=122; image[6095]=179; image[6096]=253; image[6097]=255; image[6098]=255; image[6099]=255; image[6100]=255; image[6101]=255; image[6102]=255; image[6103]=255; image[6104]=255; image[6105]=255; image[6106]=255; image[6107]=255; image[6108]=255; image[6109]=255; image[6110]=255; image[6111]=255; image[6112]=255; image[6113]=255; image[6114]=255; image[6115]=255; image[6116]=255; image[6117]=255; image[6118]=255; image[6119]=235; image[6120]=197; image[6121]=152; image[6122]=39; image[6123]=4; image[6124]=3; image[6125]=1; image[6126]=1; image[6127]=1; image[6128]=1; image[6129]=1; image[6130]=1; image[6131]=1; image[6132]=1; image[6133]=1; image[6134]=1; image[6135]=1; image[6136]=1; image[6137]=1; image[6138]=1; image[6139]=1; image[6140]=1; image[6141]=1; image[6142]=1; image[6143]=1; image[6144]=1; image[6145]=1; image[6146]=1; image[6147]=1; image[6148]=1; image[6149]=1; image[6150]=1; image[6151]=1; image[6152]=1; image[6153]=1; image[6154]=1; image[6155]=1; image[6156]=1; image[6157]=1; image[6158]=1; image[6159]=1; image[6160]=1; image[6161]=1; image[6162]=1; image[6163]=1; image[6164]=1; image[6165]=1; image[6166]=1; image[6167]=1; image[6168]=1; image[6169]=1; image[6170]=1; image[6171]=1; image[6172]=1; image[6173]=1; image[6174]=1; image[6175]=1; image[6176]=1; image[6177]=1; image[6178]=1; image[6179]=1; image[6180]=1; image[6181]=1; image[6182]=1; image[6183]=1; image[6184]=1; image[6185]=1; image[6186]=1; image[6187]=1; image[6188]=1; image[6189]=1; image[6190]=1; image[6191]=1; image[6192]=1; image[6193]=1; image[6194]=1; image[6195]=1; image[6196]=1; image[6197]=1; image[6198]=1; image[6199]=1; image[6200]=1; image[6201]=1; image[6202]=1; image[6203]=1; image[6204]=2; image[6205]=1; image[6206]=1; image[6207]=1; image[6208]=1; image[6209]=1; image[6210]=1; image[6211]=1; image[6212]=1; image[6213]=1; image[6214]=1; image[6215]=1; image[6216]=2; image[6217]=2; image[6218]=1; image[6219]=1; image[6220]=1; image[6221]=1; image[6222]=1; image[6223]=1; image[6224]=1; image[6225]=1; image[6226]=1; image[6227]=1; image[6228]=1; image[6229]=1; image[6230]=1; image[6231]=6; image[6232]=6; image[6233]=6; image[6234]=10; image[6235]=12; image[6236]=10; image[6237]=6; image[6238]=10; image[6239]=12; image[6240]=8; image[6241]=5; image[6242]=7; image[6243]=15; image[6244]=26; image[6245]=38; image[6246]=45; image[6247]=48; image[6248]=35; image[6249]=17; image[6250]=8; image[6251]=10; image[6252]=18; image[6253]=20; image[6254]=42; image[6255]=69; image[6256]=53; image[6257]=44; image[6258]=44; image[6259]=43; image[6260]=55; image[6261]=47; image[6262]=61; image[6263]=138; image[6264]=125; image[6265]=83; image[6266]=24; image[6267]=28; image[6268]=62; image[6269]=50; image[6270]=45; image[6271]=53; image[6272]=75; image[6273]=93; image[6274]=110; image[6275]=133; image[6276]=147; image[6277]=137; image[6278]=149; image[6279]=120; image[6280]=117; image[6281]=147; image[6282]=152; image[6283]=164; image[6284]=192; image[6285]=188; image[6286]=106; image[6287]=103; image[6288]=116; image[6289]=104; image[6290]=101; image[6291]=66; image[6292]=46; image[6293]=72; image[6294]=115; image[6295]=228; image[6296]=255; image[6297]=255; image[6298]=255; image[6299]=255; image[6300]=255; image[6301]=255; image[6302]=255; image[6303]=255; image[6304]=255; image[6305]=255; image[6306]=255; image[6307]=255; image[6308]=255; image[6309]=255; image[6310]=255; image[6311]=255; image[6312]=255; image[6313]=255; image[6314]=255; image[6315]=255; image[6316]=255; image[6317]=255; image[6318]=255; image[6319]=223; image[6320]=139; image[6321]=64; image[6322]=5; image[6323]=3; image[6324]=1; image[6325]=1; image[6326]=1; image[6327]=1; image[6328]=1; image[6329]=1; image[6330]=1; image[6331]=1; image[6332]=1; image[6333]=1; image[6334]=1; image[6335]=1; image[6336]=1; image[6337]=1; image[6338]=1; image[6339]=1; image[6340]=1; image[6341]=1; image[6342]=1; image[6343]=1; image[6344]=1; image[6345]=1; image[6346]=1; image[6347]=1; image[6348]=1; image[6349]=1; image[6350]=1; image[6351]=1; image[6352]=1; image[6353]=1; image[6354]=1; image[6355]=1; image[6356]=1; image[6357]=1; image[6358]=1; image[6359]=1; image[6360]=1; image[6361]=1; image[6362]=1; image[6363]=1; image[6364]=1; image[6365]=1; image[6366]=1; image[6367]=1; image[6368]=1; image[6369]=1; image[6370]=1; image[6371]=1; image[6372]=1; image[6373]=1; image[6374]=1; image[6375]=1; image[6376]=1; image[6377]=1; image[6378]=1; image[6379]=1; image[6380]=1; image[6381]=1; image[6382]=1; image[6383]=1; image[6384]=1; image[6385]=1; image[6386]=1; image[6387]=1; image[6388]=1; image[6389]=1; image[6390]=1; image[6391]=1; image[6392]=1; image[6393]=1; image[6394]=1; image[6395]=1; image[6396]=1; image[6397]=1; image[6398]=1; image[6399]=1; image[6400]=1; image[6401]=1; image[6402]=1; image[6403]=1; image[6404]=1; image[6405]=1; image[6406]=1; image[6407]=1; image[6408]=1; image[6409]=1; image[6410]=1; image[6411]=1; image[6412]=1; image[6413]=1; image[6414]=1; image[6415]=2; image[6416]=3; image[6417]=2; image[6418]=2; image[6419]=1; image[6420]=1; image[6421]=1; image[6422]=1; image[6423]=1; image[6424]=1; image[6425]=1; image[6426]=1; image[6427]=1; image[6428]=1; image[6429]=1; image[6430]=4; image[6431]=6; image[6432]=5; image[6433]=7; image[6434]=12; image[6435]=16; image[6436]=6; image[6437]=4; image[6438]=4; image[6439]=6; image[6440]=10; image[6441]=31; image[6442]=38; image[6443]=43; image[6444]=42; image[6445]=39; image[6446]=23; image[6447]=12; image[6448]=6; image[6449]=10; image[6450]=17; image[6451]=27; image[6452]=17; image[6453]=21; image[6454]=71; image[6455]=63; image[6456]=45; image[6457]=33; image[6458]=37; image[6459]=43; image[6460]=47; image[6461]=47; image[6462]=111; image[6463]=143; image[6464]=131; image[6465]=40; image[6466]=20; image[6467]=42; image[6468]=61; image[6469]=66; image[6470]=81; image[6471]=85; image[6472]=93; image[6473]=102; image[6474]=109; image[6475]=133; image[6476]=146; image[6477]=126; image[6478]=106; image[6479]=95; image[6480]=125; image[6481]=144; image[6482]=168; image[6483]=156; image[6484]=198; image[6485]=193; image[6486]=127; image[6487]=128; image[6488]=118; image[6489]=159; image[6490]=202; image[6491]=184; image[6492]=126; image[6493]=62; image[6494]=128; image[6495]=255; image[6496]=255; image[6497]=255; image[6498]=255; image[6499]=255; image[6500]=255; image[6501]=255; image[6502]=255; image[6503]=255; image[6504]=255; image[6505]=255; image[6506]=255; image[6507]=255; image[6508]=255; image[6509]=255; image[6510]=255; image[6511]=255; image[6512]=255; image[6513]=255; image[6514]=255; image[6515]=255; image[6516]=255; image[6517]=255; image[6518]=255; image[6519]=226; image[6520]=142; image[6521]=62; image[6522]=5; image[6523]=2; image[6524]=1; image[6525]=1; image[6526]=1; image[6527]=2; image[6528]=1; image[6529]=1; image[6530]=1; image[6531]=1; image[6532]=1; image[6533]=1; image[6534]=1; image[6535]=1; image[6536]=1; image[6537]=1; image[6538]=1; image[6539]=1; image[6540]=1; image[6541]=1; image[6542]=1; image[6543]=1; image[6544]=1; image[6545]=1; image[6546]=1; image[6547]=1; image[6548]=1; image[6549]=1; image[6550]=1; image[6551]=1; image[6552]=1; image[6553]=1; image[6554]=1; image[6555]=1; image[6556]=1; image[6557]=1; image[6558]=1; image[6559]=1; image[6560]=1; image[6561]=1; image[6562]=1; image[6563]=1; image[6564]=1; image[6565]=1; image[6566]=1; image[6567]=1; image[6568]=1; image[6569]=1; image[6570]=1; image[6571]=1; image[6572]=1; image[6573]=1; image[6574]=1; image[6575]=1; image[6576]=1; image[6577]=1; image[6578]=1; image[6579]=1; image[6580]=1; image[6581]=1; image[6582]=1; image[6583]=1; image[6584]=1; image[6585]=1; image[6586]=1; image[6587]=1; image[6588]=1; image[6589]=1; image[6590]=1; image[6591]=1; image[6592]=1; image[6593]=1; image[6594]=1; image[6595]=1; image[6596]=1; image[6597]=1; image[6598]=1; image[6599]=1; image[6600]=1; image[6601]=1; image[6602]=1; image[6603]=1; image[6604]=1; image[6605]=1; image[6606]=1; image[6607]=1; image[6608]=1; image[6609]=1; image[6610]=1; image[6611]=1; image[6612]=1; image[6613]=1; image[6614]=2; image[6615]=3; image[6616]=2; image[6617]=2; image[6618]=1; image[6619]=1; image[6620]=1; image[6621]=1; image[6622]=1; image[6623]=1; image[6624]=1; image[6625]=1; image[6626]=1; image[6627]=1; image[6628]=1; image[6629]=2; image[6630]=6; image[6631]=7; image[6632]=7; image[6633]=12; image[6634]=17; image[6635]=9; image[6636]=5; image[6637]=3; image[6638]=7; image[6639]=16; image[6640]=36; image[6641]=39; image[6642]=36; image[6643]=26; image[6644]=19; image[6645]=10; image[6646]=13; image[6647]=18; image[6648]=22; image[6649]=23; image[6650]=30; image[6651]=21; image[6652]=17; image[6653]=60; image[6654]=63; image[6655]=47; image[6656]=33; image[6657]=35; image[6658]=38; image[6659]=53; image[6660]=52; image[6661]=86; image[6662]=134; image[6663]=145; image[6664]=73; image[6665]=31; image[6666]=26; image[6667]=55; image[6668]=66; image[6669]=73; image[6670]=73; image[6671]=81; image[6672]=87; image[6673]=97; image[6674]=109; image[6675]=131; image[6676]=120; image[6677]=112; image[6678]=99; image[6679]=114; image[6680]=136; image[6681]=163; image[6682]=162; image[6683]=192; image[6684]=214; image[6685]=142; image[6686]=124; image[6687]=137; image[6688]=189; image[6689]=243; image[6690]=238; image[6691]=185; image[6692]=93; image[6693]=92; image[6694]=234; image[6695]=255; image[6696]=255; image[6697]=255; image[6698]=255; image[6699]=255; image[6700]=255; image[6701]=255; image[6702]=255; image[6703]=255; image[6704]=255; image[6705]=255; image[6706]=255; image[6707]=255; image[6708]=255; image[6709]=255; image[6710]=255; image[6711]=255; image[6712]=255; image[6713]=255; image[6714]=255; image[6715]=255; image[6716]=255; image[6717]=255; image[6718]=251; image[6719]=190; image[6720]=157; image[6721]=49; image[6722]=3; image[6723]=2; image[6724]=1; image[6725]=1; image[6726]=1; image[6727]=1; image[6728]=1; image[6729]=1; image[6730]=1; image[6731]=1; image[6732]=1; image[6733]=1; image[6734]=1; image[6735]=1; image[6736]=1; image[6737]=1; image[6738]=1; image[6739]=1; image[6740]=1; image[6741]=1; image[6742]=1; image[6743]=1; image[6744]=1; image[6745]=1; image[6746]=1; image[6747]=1; image[6748]=1; image[6749]=1; image[6750]=1; image[6751]=1; image[6752]=1; image[6753]=1; image[6754]=1; image[6755]=1; image[6756]=1; image[6757]=1; image[6758]=1; image[6759]=1; image[6760]=1; image[6761]=1; image[6762]=1; image[6763]=1; image[6764]=1; image[6765]=1; image[6766]=1; image[6767]=1; image[6768]=1; image[6769]=1; image[6770]=1; image[6771]=1; image[6772]=1; image[6773]=1; image[6774]=1; image[6775]=1; image[6776]=1; image[6777]=1; image[6778]=1; image[6779]=1; image[6780]=1; image[6781]=1; image[6782]=1; image[6783]=1; image[6784]=1; image[6785]=1; image[6786]=1; image[6787]=1; image[6788]=1; image[6789]=1; image[6790]=1; image[6791]=1; image[6792]=1; image[6793]=1; image[6794]=1; image[6795]=1; image[6796]=1; image[6797]=1; image[6798]=1; image[6799]=1; image[6800]=1; image[6801]=1; image[6802]=1; image[6803]=1; image[6804]=1; image[6805]=1; image[6806]=1; image[6807]=1; image[6808]=1; image[6809]=1; image[6810]=1; image[6811]=1; image[6812]=1; image[6813]=3; image[6814]=3; image[6815]=3; image[6816]=2; image[6817]=2; image[6818]=1; image[6819]=1; image[6820]=1; image[6821]=1; image[6822]=1; image[6823]=1; image[6824]=1; image[6825]=1; image[6826]=1; image[6827]=1; image[6828]=1; image[6829]=6; image[6830]=10; image[6831]=5; image[6832]=8; image[6833]=17; image[6834]=13; image[6835]=8; image[6836]=3; image[6837]=6; image[6838]=12; image[6839]=19; image[6840]=17; image[6841]=10; image[6842]=10; image[6843]=16; image[6844]=27; image[6845]=33; image[6846]=40; image[6847]=34; image[6848]=28; image[6849]=30; image[6850]=28; image[6851]=20; image[6852]=41; image[6853]=64; image[6854]=51; image[6855]=37; image[6856]=37; image[6857]=44; image[6858]=52; image[6859]=49; image[6860]=51; image[6861]=110; image[6862]=151; image[6863]=123; image[6864]=77; image[6865]=22; image[6866]=23; image[6867]=46; image[6868]=70; image[6869]=75; image[6870]=63; image[6871]=59; image[6872]=73; image[6873]=79; image[6874]=103; image[6875]=93; image[6876]=95; image[6877]=95; image[6878]=93; image[6879]=111; image[6880]=151; image[6881]=167; image[6882]=138; image[6883]=145; image[6884]=128; image[6885]=118; image[6886]=160; image[6887]=184; image[6888]=203; image[6889]=214; image[6890]=224; image[6891]=188; image[6892]=72; image[6893]=144; image[6894]=251; image[6895]=255; image[6896]=255; image[6897]=255; image[6898]=255; image[6899]=255; image[6900]=255; image[6901]=255; image[6902]=255; image[6903]=255; image[6904]=255; image[6905]=255; image[6906]=255; image[6907]=255; image[6908]=255; image[6909]=255; image[6910]=255; image[6911]=255; image[6912]=255; image[6913]=255; image[6914]=255; image[6915]=255; image[6916]=255; image[6917]=255; image[6918]=240; image[6919]=204; image[6920]=189; image[6921]=22; image[6922]=2; image[6923]=2; image[6924]=1; image[6925]=1; image[6926]=1; image[6927]=1; image[6928]=1; image[6929]=1; image[6930]=1; image[6931]=1; image[6932]=1; image[6933]=1; image[6934]=1; image[6935]=1; image[6936]=1; image[6937]=1; image[6938]=1; image[6939]=1; image[6940]=1; image[6941]=1; image[6942]=1; image[6943]=1; image[6944]=1; image[6945]=1; image[6946]=1; image[6947]=1; image[6948]=1; image[6949]=1; image[6950]=1; image[6951]=1; image[6952]=1; image[6953]=1; image[6954]=1; image[6955]=1; image[6956]=1; image[6957]=1; image[6958]=1; image[6959]=1; image[6960]=1; image[6961]=1; image[6962]=1; image[6963]=1; image[6964]=1; image[6965]=1; image[6966]=1; image[6967]=1; image[6968]=1; image[6969]=1; image[6970]=1; image[6971]=1; image[6972]=1; image[6973]=1; image[6974]=1; image[6975]=1; image[6976]=1; image[6977]=1; image[6978]=1; image[6979]=1; image[6980]=1; image[6981]=1; image[6982]=1; image[6983]=1; image[6984]=1; image[6985]=1; image[6986]=1; image[6987]=1; image[6988]=1; image[6989]=1; image[6990]=1; image[6991]=1; image[6992]=1; image[6993]=1; image[6994]=1; image[6995]=1; image[6996]=1; image[6997]=1; image[6998]=1; image[6999]=1; image[7000]=1; image[7001]=2; image[7002]=1; image[7003]=1; image[7004]=1; image[7005]=1; image[7006]=1; image[7007]=1; image[7008]=1; image[7009]=1; image[7010]=1; image[7011]=1; image[7012]=1; image[7013]=2; image[7014]=3; image[7015]=3; image[7016]=2; image[7017]=1; image[7018]=1; image[7019]=1; image[7020]=1; image[7021]=1; image[7022]=1; image[7023]=1; image[7024]=1; image[7025]=1; image[7026]=1; image[7027]=1; image[7028]=4; image[7029]=8; image[7030]=8; image[7031]=7; image[7032]=11; image[7033]=14; image[7034]=11; image[7035]=3; image[7036]=2; image[7037]=4; image[7038]=10; image[7039]=15; image[7040]=25; image[7041]=31; image[7042]=31; image[7043]=34; image[7044]=30; image[7045]=31; image[7046]=36; image[7047]=36; image[7048]=33; image[7049]=34; image[7050]=32; image[7051]=26; image[7052]=61; image[7053]=72; image[7054]=54; image[7055]=46; image[7056]=40; image[7057]=50; image[7058]=49; image[7059]=39; image[7060]=84; image[7061]=140; image[7062]=136; image[7063]=103; image[7064]=43; image[7065]=14; image[7066]=13; image[7067]=40; image[7068]=63; image[7069]=56; image[7070]=53; image[7071]=51; image[7072]=48; image[7073]=65; image[7074]=82; image[7075]=91; image[7076]=92; image[7077]=93; image[7078]=124; image[7079]=176; image[7080]=164; image[7081]=125; image[7082]=135; image[7083]=154; image[7084]=162; image[7085]=189; image[7086]=199; image[7087]=207; image[7088]=210; image[7089]=208; image[7090]=219; image[7091]=109; image[7092]=87; image[7093]=230; image[7094]=255; image[7095]=255; image[7096]=255; image[7097]=255; image[7098]=255; image[7099]=255; image[7100]=255; image[7101]=255; image[7102]=255; image[7103]=255; image[7104]=255; image[7105]=255; image[7106]=255; image[7107]=255; image[7108]=255; image[7109]=255; image[7110]=255; image[7111]=255; image[7112]=255; image[7113]=255; image[7114]=255; image[7115]=255; image[7116]=255; image[7117]=255; image[7118]=191; image[7119]=159; image[7120]=66; image[7121]=2; image[7122]=3; image[7123]=1; image[7124]=1; image[7125]=1; image[7126]=1; image[7127]=1; image[7128]=1; image[7129]=1; image[7130]=1; image[7131]=1; image[7132]=1; image[7133]=1; image[7134]=1; image[7135]=1; image[7136]=1; image[7137]=1; image[7138]=1; image[7139]=1; image[7140]=1; image[7141]=1; image[7142]=1; image[7143]=1; image[7144]=1; image[7145]=1; image[7146]=1; image[7147]=1; image[7148]=1; image[7149]=1; image[7150]=1; image[7151]=1; image[7152]=1; image[7153]=1; image[7154]=1; image[7155]=1; image[7156]=1; image[7157]=1; image[7158]=1; image[7159]=1; image[7160]=1; image[7161]=1; image[7162]=1; image[7163]=1; image[7164]=1; image[7165]=1; image[7166]=1; image[7167]=1; image[7168]=1; image[7169]=1; image[7170]=1; image[7171]=1; image[7172]=1; image[7173]=1; image[7174]=1; image[7175]=1; image[7176]=1; image[7177]=1; image[7178]=1; image[7179]=1; image[7180]=1; image[7181]=1; image[7182]=1; image[7183]=1; image[7184]=1; image[7185]=1; image[7186]=1; image[7187]=1; image[7188]=1; image[7189]=1; image[7190]=1; image[7191]=1; image[7192]=1; image[7193]=1; image[7194]=1; image[7195]=1; image[7196]=1; image[7197]=1; image[7198]=1; image[7199]=1; image[7200]=1; image[7201]=1; image[7202]=1; image[7203]=1; image[7204]=1; image[7205]=1; image[7206]=1; image[7207]=1; image[7208]=1; image[7209]=1; image[7210]=1; image[7211]=1; image[7212]=2; image[7213]=3; image[7214]=3; image[7215]=2; image[7216]=2; image[7217]=1; image[7218]=1; image[7219]=1; image[7220]=1; image[7221]=1; image[7222]=1; image[7223]=1; image[7224]=1; image[7225]=1; image[7226]=1; image[7227]=2; image[7228]=6; image[7229]=10; image[7230]=7; image[7231]=8; image[7232]=13; image[7233]=10; image[7234]=3; image[7235]=4; image[7236]=8; image[7237]=22; image[7238]=29; image[7239]=33; image[7240]=34; image[7241]=31; image[7242]=32; image[7243]=29; image[7244]=27; image[7245]=36; image[7246]=38; image[7247]=38; image[7248]=37; image[7249]=37; image[7250]=27; image[7251]=63; image[7252]=85; image[7253]=59; image[7254]=49; image[7255]=38; image[7256]=46; image[7257]=48; image[7258]=37; image[7259]=64; image[7260]=116; image[7261]=141; image[7262]=119; image[7263]=64; image[7264]=23; image[7265]=11; image[7266]=25; image[7267]=52; image[7268]=61; image[7269]=55; image[7270]=45; image[7271]=45; image[7272]=60; image[7273]=90; image[7274]=110; image[7275]=119; image[7276]=138; image[7277]=154; image[7278]=159; image[7279]=139; image[7280]=128; image[7281]=136; image[7282]=163; image[7283]=191; image[7284]=210; image[7285]=212; image[7286]=213; image[7287]=202; image[7288]=194; image[7289]=189; image[7290]=114; image[7291]=65; image[7292]=202; image[7293]=255; image[7294]=255; image[7295]=255; image[7296]=255; image[7297]=255; image[7298]=255; image[7299]=255; image[7300]=255; image[7301]=255; image[7302]=255; image[7303]=255; image[7304]=255; image[7305]=255; image[7306]=255; image[7307]=255; image[7308]=255; image[7309]=255; image[7310]=255; image[7311]=255; image[7312]=255; image[7313]=255; image[7314]=255; image[7315]=255; image[7316]=255; image[7317]=201; image[7318]=69; image[7319]=51; image[7320]=4; image[7321]=3; image[7322]=1; image[7323]=1; image[7324]=1; image[7325]=1; image[7326]=1; image[7327]=1; image[7328]=1; image[7329]=1; image[7330]=1; image[7331]=1; image[7332]=1; image[7333]=1; image[7334]=1; image[7335]=1; image[7336]=1; image[7337]=1; image[7338]=1; image[7339]=1; image[7340]=1; image[7341]=1; image[7342]=1; image[7343]=1; image[7344]=1; image[7345]=1; image[7346]=1; image[7347]=1; image[7348]=1; image[7349]=1; image[7350]=1; image[7351]=1; image[7352]=1; image[7353]=1; image[7354]=1; image[7355]=1; image[7356]=1; image[7357]=1; image[7358]=1; image[7359]=1; image[7360]=1; image[7361]=1; image[7362]=1; image[7363]=1; image[7364]=1; image[7365]=1; image[7366]=1; image[7367]=1; image[7368]=1; image[7369]=1; image[7370]=1; image[7371]=1; image[7372]=1; image[7373]=1; image[7374]=1; image[7375]=1; image[7376]=1; image[7377]=1; image[7378]=1; image[7379]=1; image[7380]=1; image[7381]=1; image[7382]=1; image[7383]=1; image[7384]=1; image[7385]=1; image[7386]=1; image[7387]=1; image[7388]=1; image[7389]=1; image[7390]=1; image[7391]=1; image[7392]=1; image[7393]=1; image[7394]=1; image[7395]=1; image[7396]=1; image[7397]=1; image[7398]=1; image[7399]=1; image[7400]=2; image[7401]=2; image[7402]=1; image[7403]=1; image[7404]=1; image[7405]=1; image[7406]=1; image[7407]=1; image[7408]=1; image[7409]=1; image[7410]=1; image[7411]=2; image[7412]=2; image[7413]=3; image[7414]=2; image[7415]=2; image[7416]=1; image[7417]=1; image[7418]=1; image[7419]=1; image[7420]=1; image[7421]=1; image[7422]=1; image[7423]=1; image[7424]=1; image[7425]=1; image[7426]=1; image[7427]=3; image[7428]=8; image[7429]=8; image[7430]=6; image[7431]=11; image[7432]=11; image[7433]=12; image[7434]=20; image[7435]=26; image[7436]=30; image[7437]=34; image[7438]=34; image[7439]=32; image[7440]=32; image[7441]=35; image[7442]=34; image[7443]=30; image[7444]=36; image[7445]=40; image[7446]=41; image[7447]=41; image[7448]=44; image[7449]=48; image[7450]=64; image[7451]=89; image[7452]=59; image[7453]=46; image[7454]=38; image[7455]=40; image[7456]=42; image[7457]=42; image[7458]=44; image[7459]=76; image[7460]=131; image[7461]=129; image[7462]=104; image[7463]=43; image[7464]=13; image[7465]=14; image[7466]=47; image[7467]=82; image[7468]=67; image[7469]=46; image[7470]=39; image[7471]=46; image[7472]=58; image[7473]=62; image[7474]=77; image[7475]=105; image[7476]=84; image[7477]=91; image[7478]=137; image[7479]=152; image[7480]=150; image[7481]=157; image[7482]=181; image[7483]=177; image[7484]=154; image[7485]=185; image[7486]=211; image[7487]=202; image[7488]=180; image[7489]=121; image[7490]=55; image[7491]=106; image[7492]=245; image[7493]=255; image[7494]=255; image[7495]=255; image[7496]=255; image[7497]=255; image[7498]=255; image[7499]=255; image[7500]=255; image[7501]=255; image[7502]=255; image[7503]=255; image[7504]=255; image[7505]=255; image[7506]=255; image[7507]=255; image[7508]=255; image[7509]=255; image[7510]=255; image[7511]=255; image[7512]=255; image[7513]=255; image[7514]=255; image[7515]=255; image[7516]=255; image[7517]=200; image[7518]=87; image[7519]=31; image[7520]=2; image[7521]=1; image[7522]=1; image[7523]=1; image[7524]=1; image[7525]=1; image[7526]=1; image[7527]=1; image[7528]=1; image[7529]=1; image[7530]=1; image[7531]=1; image[7532]=1; image[7533]=1; image[7534]=1; image[7535]=1; image[7536]=1; image[7537]=1; image[7538]=1; image[7539]=1; image[7540]=1; image[7541]=1; image[7542]=1; image[7543]=1; image[7544]=1; image[7545]=1; image[7546]=1; image[7547]=1; image[7548]=1; image[7549]=1; image[7550]=1; image[7551]=1; image[7552]=1; image[7553]=1; image[7554]=1; image[7555]=1; image[7556]=1; image[7557]=1; image[7558]=1; image[7559]=1; image[7560]=1; image[7561]=1; image[7562]=1; image[7563]=1; image[7564]=1; image[7565]=1; image[7566]=1; image[7567]=1; image[7568]=1; image[7569]=1; image[7570]=1; image[7571]=1; image[7572]=1; image[7573]=1; image[7574]=1; image[7575]=1; image[7576]=1; image[7577]=1; image[7578]=1; image[7579]=0; image[7580]=1; image[7581]=1; image[7582]=1; image[7583]=1; image[7584]=1; image[7585]=1; image[7586]=1; image[7587]=1; image[7588]=1; image[7589]=1; image[7590]=1; image[7591]=1; image[7592]=1; image[7593]=1; image[7594]=1; image[7595]=1; image[7596]=1; image[7597]=1; image[7598]=1; image[7599]=2; image[7600]=1; image[7601]=1; image[7602]=1; image[7603]=1; image[7604]=1; image[7605]=1; image[7606]=1; image[7607]=1; image[7608]=1; image[7609]=1; image[7610]=2; image[7611]=2; image[7612]=3; image[7613]=2; image[7614]=2; image[7615]=1; image[7616]=1; image[7617]=1; image[7618]=1; image[7619]=1; image[7620]=1; image[7621]=1; image[7622]=1; image[7623]=1; image[7624]=1; image[7625]=1; image[7626]=2; image[7627]=9; image[7628]=9; image[7629]=7; image[7630]=9; image[7631]=11; image[7632]=13; image[7633]=17; image[7634]=21; image[7635]=24; image[7636]=26; image[7637]=29; image[7638]=29; image[7639]=30; image[7640]=31; image[7641]=30; image[7642]=28; image[7643]=29; image[7644]=33; image[7645]=34; image[7646]=39; image[7647]=46; image[7648]=55; image[7649]=52; image[7650]=73; image[7651]=75; image[7652]=55; image[7653]=43; image[7654]=36; image[7655]=37; image[7656]=43; image[7657]=44; image[7658]=56; image[7659]=125; image[7660]=133; image[7661]=131; image[7662]=90; image[7663]=30; image[7664]=11; image[7665]=27; image[7666]=68; image[7667]=89; image[7668]=81; image[7669]=64; image[7670]=65; image[7671]=68; image[7672]=77; image[7673]=73; image[7674]=69; image[7675]=83; image[7676]=115; image[7677]=152; image[7678]=188; image[7679]=211; image[7680]=208; image[7681]=182; image[7682]=148; image[7683]=140; image[7684]=158; image[7685]=214; image[7686]=229; image[7687]=232; image[7688]=147; image[7689]=52; image[7690]=67; image[7691]=211; image[7692]=255; image[7693]=255; image[7694]=255; image[7695]=255; image[7696]=255; image[7697]=255; image[7698]=255; image[7699]=255; image[7700]=255; image[7701]=255; image[7702]=255; image[7703]=255; image[7704]=255; image[7705]=255; image[7706]=255; image[7707]=255; image[7708]=255; image[7709]=255; image[7710]=255; image[7711]=255; image[7712]=255; image[7713]=255; image[7714]=255; image[7715]=255; image[7716]=248; image[7717]=178; image[7718]=139; image[7719]=20; image[7720]=2; image[7721]=2; image[7722]=1; image[7723]=1; image[7724]=1; image[7725]=1; image[7726]=1; image[7727]=1; image[7728]=1; image[7729]=1; image[7730]=1; image[7731]=1; image[7732]=1; image[7733]=1; image[7734]=1; image[7735]=1; image[7736]=1; image[7737]=1; image[7738]=1; image[7739]=1; image[7740]=1; image[7741]=1; image[7742]=1; image[7743]=1; image[7744]=1; image[7745]=1; image[7746]=1; image[7747]=1; image[7748]=1; image[7749]=1; image[7750]=1; image[7751]=1; image[7752]=1; image[7753]=1; image[7754]=1; image[7755]=1; image[7756]=1; image[7757]=1; image[7758]=1; image[7759]=1; image[7760]=1; image[7761]=1; image[7762]=1; image[7763]=1; image[7764]=1; image[7765]=1; image[7766]=1; image[7767]=1; image[7768]=1; image[7769]=1; image[7770]=1; image[7771]=1; image[7772]=1; image[7773]=1; image[7774]=1; image[7775]=1; image[7776]=1; image[7777]=1; image[7778]=1; image[7779]=1; image[7780]=1; image[7781]=1; image[7782]=1; image[7783]=1; image[7784]=1; image[7785]=1; image[7786]=1; image[7787]=1; image[7788]=1; image[7789]=1; image[7790]=1; image[7791]=1; image[7792]=1; image[7793]=1; image[7794]=1; image[7795]=1; image[7796]=1; image[7797]=2; image[7798]=1; image[7799]=1; image[7800]=1; image[7801]=1; image[7802]=1; image[7803]=1; image[7804]=1; image[7805]=1; image[7806]=1; image[7807]=1; image[7808]=1; image[7809]=1; image[7810]=2; image[7811]=2; image[7812]=2; image[7813]=2; image[7814]=2; image[7815]=1; image[7816]=1; image[7817]=1; image[7818]=1; image[7819]=1; image[7820]=1; image[7821]=1; image[7822]=1; image[7823]=1; image[7824]=1; image[7825]=1; image[7826]=7; image[7827]=9; image[7828]=7; image[7829]=9; image[7830]=11; image[7831]=12; image[7832]=14; image[7833]=16; image[7834]=21; image[7835]=25; image[7836]=30; image[7837]=26; image[7838]=28; image[7839]=30; image[7840]=28; image[7841]=27; image[7842]=23; image[7843]=27; image[7844]=34; image[7845]=37; image[7846]=37; image[7847]=41; image[7848]=28; image[7849]=38; image[7850]=89; image[7851]=64; image[7852]=38; image[7853]=32; image[7854]=34; image[7855]=41; image[7856]=46; image[7857]=47; image[7858]=112; image[7859]=132; image[7860]=144; image[7861]=143; image[7862]=69; image[7863]=19; image[7864]=15; image[7865]=60; image[7866]=68; image[7867]=41; image[7868]=44; image[7869]=66; image[7870]=80; image[7871]=125; image[7872]=158; image[7873]=144; image[7874]=144; image[7875]=143; image[7876]=192; image[7877]=248; image[7878]=245; image[7879]=255; image[7880]=232; image[7881]=157; image[7882]=156; image[7883]=158; image[7884]=223; image[7885]=255; image[7886]=255; image[7887]=158; image[7888]=47; image[7889]=50; image[7890]=158; image[7891]=255; image[7892]=255; image[7893]=255; image[7894]=255; image[7895]=255; image[7896]=255; image[7897]=255; image[7898]=255; image[7899]=255; image[7900]=255; image[7901]=255; image[7902]=255; image[7903]=255; image[7904]=255; image[7905]=255; image[7906]=255; image[7907]=255; image[7908]=255; image[7909]=255; image[7910]=255; image[7911]=255; image[7912]=255; image[7913]=255; image[7914]=255; image[7915]=252; image[7916]=196; image[7917]=208; image[7918]=54; image[7919]=2; image[7920]=2; image[7921]=1; image[7922]=1; image[7923]=1; image[7924]=1; image[7925]=1; image[7926]=1; image[7927]=1; image[7928]=1; image[7929]=1; image[7930]=1; image[7931]=1; image[7932]=1; image[7933]=1; image[7934]=1; image[7935]=1; image[7936]=1; image[7937]=1; image[7938]=1; image[7939]=1; image[7940]=1; image[7941]=1; image[7942]=1; image[7943]=1; image[7944]=1; image[7945]=1; image[7946]=1; image[7947]=1; image[7948]=1; image[7949]=1; image[7950]=1; image[7951]=1; image[7952]=1; image[7953]=1; image[7954]=1; image[7955]=1; image[7956]=1; image[7957]=1; image[7958]=1; image[7959]=1; image[7960]=1; image[7961]=1; image[7962]=1; image[7963]=1; image[7964]=1; image[7965]=1; image[7966]=1; image[7967]=1; image[7968]=1; image[7969]=1; image[7970]=1; image[7971]=1; image[7972]=1; image[7973]=1; image[7974]=1; image[7975]=1; image[7976]=1; image[7977]=1; image[7978]=1; image[7979]=1; image[7980]=1; image[7981]=1; image[7982]=1; image[7983]=1; image[7984]=1; image[7985]=1; image[7986]=1; image[7987]=1; image[7988]=1; image[7989]=1; image[7990]=1; image[7991]=1; image[7992]=1; image[7993]=1; image[7994]=1; image[7995]=1; image[7996]=1; image[7997]=1; image[7998]=1; image[7999]=1; image[8000]=1; image[8001]=1; image[8002]=1; image[8003]=1; image[8004]=1; image[8005]=1; image[8006]=1; image[8007]=1; image[8008]=1; image[8009]=1; image[8010]=1; image[8011]=1; image[8012]=1; image[8013]=1; image[8014]=1; image[8015]=1; image[8016]=1; image[8017]=1; image[8018]=1; image[8019]=1; image[8020]=1; image[8021]=1; image[8022]=1; image[8023]=1; image[8024]=1; image[8025]=4; image[8026]=9; image[8027]=8; image[8028]=6; image[8029]=8; image[8030]=10; image[8031]=10; image[8032]=11; image[8033]=22; image[8034]=25; image[8035]=27; image[8036]=27; image[8037]=29; image[8038]=28; image[8039]=27; image[8040]=24; image[8041]=26; image[8042]=28; image[8043]=31; image[8044]=33; image[8045]=37; image[8046]=41; image[8047]=29; image[8048]=15; image[8049]=69; image[8050]=89; image[8051]=57; image[8052]=44; image[8053]=39; image[8054]=39; image[8055]=48; image[8056]=46; image[8057]=49; image[8058]=67; image[8059]=88; image[8060]=94; image[8061]=87; image[8062]=43; image[8063]=29; image[8064]=81; image[8065]=173; image[8066]=166; image[8067]=99; image[8068]=78; image[8069]=89; image[8070]=122; image[8071]=161; image[8072]=160; image[8073]=219; image[8074]=255; image[8075]=255; image[8076]=255; image[8077]=230; image[8078]=209; image[8079]=249; image[8080]=250; image[8081]=231; image[8082]=240; image[8083]=254; image[8084]=255; image[8085]=255; image[8086]=127; image[8087]=53; image[8088]=70; image[8089]=93; image[8090]=200; image[8091]=255; image[8092]=255; image[8093]=255; image[8094]=255; image[8095]=255; image[8096]=255; image[8097]=255; image[8098]=255; image[8099]=255; image[8100]=255; image[8101]=255; image[8102]=255; image[8103]=255; image[8104]=255; image[8105]=255; image[8106]=255; image[8107]=255; image[8108]=255; image[8109]=255; image[8110]=255; image[8111]=255; image[8112]=255; image[8113]=255; image[8114]=255; image[8115]=214; image[8116]=155; image[8117]=151; image[8118]=16; image[8119]=2; image[8120]=1; image[8121]=1; image[8122]=1; image[8123]=1; image[8124]=1; image[8125]=1; image[8126]=1; image[8127]=1; image[8128]=1; image[8129]=1; image[8130]=1; image[8131]=1; image[8132]=1; image[8133]=1; image[8134]=1; image[8135]=1; image[8136]=1; image[8137]=1; image[8138]=1; image[8139]=1; image[8140]=1; image[8141]=1; image[8142]=1; image[8143]=1; image[8144]=1; image[8145]=1; image[8146]=1; image[8147]=1; image[8148]=1; image[8149]=1; image[8150]=1; image[8151]=1; image[8152]=1; image[8153]=1; image[8154]=1; image[8155]=1; image[8156]=1; image[8157]=1; image[8158]=1; image[8159]=1; image[8160]=1; image[8161]=1; image[8162]=1; image[8163]=1; image[8164]=1; image[8165]=1; image[8166]=1; image[8167]=1; image[8168]=1; image[8169]=1; image[8170]=1; image[8171]=1; image[8172]=1; image[8173]=1; image[8174]=1; image[8175]=1; image[8176]=1; image[8177]=1; image[8178]=1; image[8179]=1; image[8180]=1; image[8181]=1; image[8182]=1; image[8183]=1; image[8184]=1; image[8185]=1; image[8186]=1; image[8187]=1; image[8188]=1; image[8189]=1; image[8190]=1; image[8191]=1; image[8192]=1; image[8193]=1; image[8194]=1; image[8195]=1; image[8196]=1; image[8197]=1; image[8198]=1; image[8199]=1; image[8200]=1; image[8201]=1; image[8202]=1; image[8203]=1; image[8204]=1; image[8205]=1; image[8206]=1; image[8207]=1; image[8208]=1; image[8209]=1; image[8210]=1; image[8211]=1; image[8212]=1; image[8213]=1; image[8214]=1; image[8215]=1; image[8216]=1; image[8217]=1; image[8218]=1; image[8219]=1; image[8220]=1; image[8221]=1; image[8222]=1; image[8223]=1; image[8224]=3; image[8225]=7; image[8226]=9; image[8227]=6; image[8228]=7; image[8229]=9; image[8230]=10; image[8231]=10; image[8232]=18; image[8233]=21; image[8234]=20; image[8235]=26; image[8236]=28; image[8237]=28; image[8238]=30; image[8239]=30; image[8240]=29; image[8241]=29; image[8242]=32; image[8243]=35; image[8244]=37; image[8245]=37; image[8246]=33; image[8247]=19; image[8248]=42; image[8249]=78; image[8250]=63; image[8251]=42; image[8252]=38; image[8253]=39; image[8254]=46; image[8255]=49; image[8256]=40; image[8257]=58; image[8258]=99; image[8259]=84; image[8260]=68; image[8261]=36; image[8262]=25; image[8263]=49; image[8264]=180; image[8265]=232; image[8266]=169; image[8267]=111; image[8268]=110; image[8269]=129; image[8270]=154; image[8271]=145; image[8272]=174; image[8273]=201; image[8274]=224; image[8275]=255; image[8276]=255; image[8277]=220; image[8278]=200; image[8279]=238; image[8280]=246; image[8281]=251; image[8282]=254; image[8283]=255; image[8284]=255; image[8285]=173; image[8286]=143; image[8287]=122; image[8288]=129; image[8289]=187; image[8290]=234; image[8291]=253; image[8292]=255; image[8293]=255; image[8294]=255; image[8295]=255; image[8296]=255; image[8297]=255; image[8298]=255; image[8299]=255; image[8300]=255; image[8301]=255; image[8302]=255; image[8303]=255; image[8304]=255; image[8305]=255; image[8306]=255; image[8307]=255; image[8308]=255; image[8309]=255; image[8310]=255; image[8311]=255; image[8312]=255; image[8313]=255; image[8314]=235; image[8315]=135; image[8316]=172; image[8317]=28; image[8318]=2; image[8319]=1; image[8320]=1; image[8321]=1; image[8322]=1; image[8323]=1; image[8324]=1; image[8325]=1; image[8326]=1; image[8327]=1; image[8328]=1; image[8329]=1; image[8330]=1; image[8331]=1; image[8332]=1; image[8333]=1; image[8334]=1; image[8335]=1; image[8336]=1; image[8337]=1; image[8338]=1; image[8339]=1; image[8340]=1; image[8341]=1; image[8342]=1; image[8343]=1; image[8344]=1; image[8345]=1; image[8346]=1; image[8347]=1; image[8348]=1; image[8349]=1; image[8350]=1; image[8351]=1; image[8352]=1; image[8353]=1; image[8354]=1; image[8355]=1; image[8356]=1; image[8357]=1; image[8358]=1; image[8359]=1; image[8360]=1; image[8361]=1; image[8362]=1; image[8363]=1; image[8364]=1; image[8365]=1; image[8366]=1; image[8367]=1; image[8368]=1; image[8369]=1; image[8370]=1; image[8371]=1; image[8372]=1; image[8373]=1; image[8374]=1; image[8375]=1; image[8376]=1; image[8377]=1; image[8378]=1; image[8379]=1; image[8380]=1; image[8381]=1; image[8382]=1; image[8383]=1; image[8384]=1; image[8385]=1; image[8386]=1; image[8387]=1; image[8388]=1; image[8389]=1; image[8390]=1; image[8391]=1; image[8392]=1; image[8393]=1; image[8394]=1; image[8395]=1; image[8396]=1; image[8397]=2; image[8398]=2; image[8399]=1; image[8400]=1; image[8401]=1; image[8402]=1; image[8403]=1; image[8404]=1; image[8405]=1; image[8406]=1; image[8407]=1; image[8408]=1; image[8409]=1; image[8410]=1; image[8411]=1; image[8412]=1; image[8413]=1; image[8414]=1; image[8415]=1; image[8416]=1; image[8417]=1; image[8418]=1; image[8419]=1; image[8420]=1; image[8421]=1; image[8422]=1; image[8423]=1; image[8424]=4; image[8425]=10; image[8426]=6; image[8427]=6; image[8428]=9; image[8429]=11; image[8430]=12; image[8431]=11; image[8432]=16; image[8433]=23; image[8434]=26; image[8435]=26; image[8436]=30; image[8437]=34; image[8438]=36; image[8439]=29; image[8440]=28; image[8441]=31; image[8442]=33; image[8443]=30; image[8444]=28; image[8445]=31; image[8446]=28; image[8447]=13; image[8448]=41; image[8449]=68; image[8450]=46; image[8451]=43; image[8452]=40; image[8453]=41; image[8454]=46; image[8455]=39; image[8456]=46; image[8457]=94; image[8458]=95; image[8459]=69; image[8460]=41; image[8461]=19; image[8462]=20; image[8463]=59; image[8464]=108; image[8465]=132; image[8466]=123; image[8467]=97; image[8468]=119; image[8469]=190; image[8470]=237; image[8471]=189; image[8472]=136; image[8473]=183; image[8474]=255; image[8475]=255; image[8476]=255; image[8477]=206; image[8478]=175; image[8479]=228; image[8480]=241; image[8481]=251; image[8482]=255; image[8483]=253; image[8484]=255; image[8485]=255; image[8486]=237; image[8487]=240; image[8488]=228; image[8489]=196; image[8490]=246; image[8491]=255; image[8492]=255; image[8493]=255; image[8494]=255; image[8495]=255; image[8496]=255; image[8497]=255; image[8498]=255; image[8499]=255; image[8500]=255; image[8501]=255; image[8502]=255; image[8503]=255; image[8504]=255; image[8505]=255; image[8506]=255; image[8507]=255; image[8508]=255; image[8509]=255; image[8510]=255; image[8511]=255; image[8512]=255; image[8513]=255; image[8514]=159; image[8515]=152; image[8516]=46; image[8517]=3; image[8518]=2; image[8519]=1; image[8520]=1; image[8521]=2; image[8522]=1; image[8523]=1; image[8524]=1; image[8525]=1; image[8526]=1; image[8527]=1; image[8528]=1; image[8529]=1; image[8530]=1; image[8531]=1; image[8532]=1; image[8533]=1; image[8534]=1; image[8535]=1; image[8536]=1; image[8537]=1; image[8538]=1; image[8539]=1; image[8540]=1; image[8541]=1; image[8542]=1; image[8543]=1; image[8544]=1; image[8545]=1; image[8546]=1; image[8547]=1; image[8548]=1; image[8549]=1; image[8550]=1; image[8551]=1; image[8552]=1; image[8553]=1; image[8554]=1; image[8555]=1; image[8556]=1; image[8557]=1; image[8558]=1; image[8559]=1; image[8560]=1; image[8561]=1; image[8562]=1; image[8563]=1; image[8564]=1; image[8565]=1; image[8566]=1; image[8567]=1; image[8568]=1; image[8569]=1; image[8570]=1; image[8571]=1; image[8572]=1; image[8573]=1; image[8574]=1; image[8575]=1; image[8576]=1; image[8577]=1; image[8578]=1; image[8579]=1; image[8580]=1; image[8581]=1; image[8582]=1; image[8583]=1; image[8584]=1; image[8585]=1; image[8586]=1; image[8587]=1; image[8588]=1; image[8589]=1; image[8590]=1; image[8591]=1; image[8592]=2; image[8593]=1; image[8594]=1; image[8595]=1; image[8596]=1; image[8597]=1; image[8598]=1; image[8599]=1; image[8600]=1; image[8601]=1; image[8602]=1; image[8603]=1; image[8604]=1; image[8605]=1; image[8606]=1; image[8607]=1; image[8608]=1; image[8609]=1; image[8610]=1; image[8611]=1; image[8612]=1; image[8613]=1; image[8614]=1; image[8615]=1; image[8616]=1; image[8617]=1; image[8618]=1; image[8619]=1; image[8620]=1; image[8621]=1; image[8622]=1; image[8623]=2; image[8624]=8; image[8625]=8; image[8626]=6; image[8627]=7; image[8628]=9; image[8629]=11; image[8630]=10; image[8631]=15; image[8632]=26; image[8633]=26; image[8634]=30; image[8635]=30; image[8636]=31; image[8637]=33; image[8638]=30; image[8639]=25; image[8640]=22; image[8641]=25; image[8642]=24; image[8643]=24; image[8644]=27; image[8645]=29; image[8646]=13; image[8647]=21; image[8648]=60; image[8649]=52; image[8650]=44; image[8651]=35; image[8652]=37; image[8653]=38; image[8654]=42; image[8655]=46; image[8656]=73; image[8657]=118; image[8658]=113; image[8659]=81; image[8660]=31; image[8661]=22; image[8662]=89; image[8663]=202; image[8664]=239; image[8665]=227; image[8666]=156; image[8667]=171; image[8668]=226; image[8669]=255; image[8670]=213; image[8671]=189; image[8672]=232; image[8673]=255; image[8674]=255; image[8675]=255; image[8676]=250; image[8677]=241; image[8678]=252; image[8679]=255; image[8680]=254; image[8681]=255; image[8682]=255; image[8683]=255; image[8684]=255; image[8685]=255; image[8686]=255; image[8687]=255; image[8688]=249; image[8689]=254; image[8690]=255; image[8691]=255; image[8692]=255; image[8693]=255; image[8694]=255; image[8695]=255; image[8696]=255; image[8697]=255; image[8698]=255; image[8699]=255; image[8700]=255; image[8701]=255; image[8702]=255; image[8703]=255; image[8704]=255; image[8705]=255; image[8706]=255; image[8707]=255; image[8708]=255; image[8709]=255; image[8710]=255; image[8711]=255; image[8712]=255; image[8713]=158; image[8714]=111; image[8715]=70; image[8716]=4; image[8717]=2; image[8718]=1; image[8719]=1; image[8720]=1; image[8721]=1; image[8722]=1; image[8723]=1; image[8724]=1; image[8725]=1; image[8726]=1; image[8727]=1; image[8728]=0; image[8729]=1; image[8730]=1; image[8731]=1; image[8732]=1; image[8733]=1; image[8734]=1; image[8735]=1; image[8736]=1; image[8737]=1; image[8738]=1; image[8739]=1; image[8740]=1; image[8741]=1; image[8742]=1; image[8743]=1; image[8744]=1; image[8745]=1; image[8746]=1; image[8747]=1; image[8748]=1; image[8749]=1; image[8750]=1; image[8751]=1; image[8752]=1; image[8753]=1; image[8754]=1; image[8755]=1; image[8756]=1; image[8757]=1; image[8758]=1; image[8759]=1; image[8760]=1; image[8761]=1; image[8762]=1; image[8763]=1; image[8764]=1; image[8765]=1; image[8766]=1; image[8767]=1; image[8768]=1; image[8769]=1; image[8770]=1; image[8771]=1; image[8772]=1; image[8773]=1; image[8774]=1; image[8775]=1; image[8776]=1; image[8777]=1; image[8778]=1; image[8779]=1; image[8780]=1; image[8781]=1; image[8782]=1; image[8783]=1; image[8784]=1; image[8785]=1; image[8786]=1; image[8787]=1; image[8788]=1; image[8789]=1; image[8790]=1; image[8791]=1; image[8792]=1; image[8793]=1; image[8794]=1; image[8795]=1; image[8796]=1; image[8797]=1; image[8798]=1; image[8799]=1; image[8800]=1; image[8801]=1; image[8802]=1; image[8803]=1; image[8804]=1; image[8805]=1; image[8806]=1; image[8807]=1; image[8808]=1; image[8809]=1; image[8810]=1; image[8811]=1; image[8812]=1; image[8813]=1; image[8814]=1; image[8815]=1; image[8816]=1; image[8817]=1; image[8818]=1; image[8819]=1; image[8820]=1; image[8821]=1; image[8822]=2; image[8823]=8; image[8824]=8; image[8825]=7; image[8826]=6; image[8827]=9; image[8828]=11; image[8829]=10; image[8830]=15; image[8831]=26; image[8832]=26; image[8833]=30; image[8834]=32; image[8835]=29; image[8836]=27; image[8837]=27; image[8838]=24; image[8839]=20; image[8840]=22; image[8841]=22; image[8842]=25; image[8843]=24; image[8844]=17; image[8845]=8; image[8846]=11; image[8847]=44; image[8848]=53; image[8849]=43; image[8850]=37; image[8851]=37; image[8852]=38; image[8853]=42; image[8854]=46; image[8855]=57; image[8856]=116; image[8857]=126; image[8858]=95; image[8859]=44; image[8860]=21; image[8861]=41; image[8862]=115; image[8863]=181; image[8864]=207; image[8865]=194; image[8866]=185; image[8867]=203; image[8868]=228; image[8869]=214; image[8870]=211; image[8871]=250; image[8872]=255; image[8873]=255; image[8874]=255; image[8875]=255; image[8876]=255; image[8877]=255; image[8878]=255; image[8879]=255; image[8880]=255; image[8881]=255; image[8882]=255; image[8883]=255; image[8884]=255; image[8885]=255; image[8886]=255; image[8887]=255; image[8888]=255; image[8889]=255; image[8890]=255; image[8891]=255; image[8892]=255; image[8893]=255; image[8894]=255; image[8895]=255; image[8896]=255; image[8897]=255; image[8898]=255; image[8899]=255; image[8900]=255; image[8901]=255; image[8902]=255; image[8903]=255; image[8904]=255; image[8905]=255; image[8906]=255; image[8907]=255; image[8908]=255; image[8909]=255; image[8910]=255; image[8911]=255; image[8912]=168; image[8913]=79; image[8914]=85; image[8915]=8; image[8916]=2; image[8917]=1; image[8918]=1; image[8919]=1; image[8920]=1; image[8921]=1; image[8922]=1; image[8923]=1; image[8924]=1; image[8925]=1; image[8926]=1; image[8927]=1; image[8928]=1; image[8929]=1; image[8930]=1; image[8931]=1; image[8932]=1; image[8933]=1; image[8934]=1; image[8935]=1; image[8936]=1; image[8937]=1; image[8938]=1; image[8939]=1; image[8940]=1; image[8941]=1; image[8942]=1; image[8943]=1; image[8944]=1; image[8945]=1; image[8946]=1; image[8947]=1; image[8948]=1; image[8949]=1; image[8950]=1; image[8951]=1; image[8952]=1; image[8953]=1; image[8954]=1; image[8955]=1; image[8956]=1; image[8957]=1; image[8958]=1; image[8959]=1; image[8960]=1; image[8961]=1; image[8962]=1; image[8963]=1; image[8964]=1; image[8965]=1; image[8966]=1; image[8967]=1; image[8968]=1; image[8969]=1; image[8970]=1; image[8971]=1; image[8972]=1; image[8973]=1; image[8974]=1; image[8975]=1; image[8976]=1; image[8977]=1; image[8978]=1; image[8979]=1; image[8980]=1; image[8981]=1; image[8982]=1; image[8983]=1; image[8984]=1; image[8985]=1; image[8986]=1; image[8987]=1; image[8988]=1; image[8989]=1; image[8990]=1; image[8991]=1; image[8992]=1; image[8993]=1; image[8994]=1; image[8995]=1; image[8996]=1; image[8997]=1; image[8998]=1; image[8999]=1; image[9000]=1; image[9001]=1; image[9002]=1; image[9003]=1; image[9004]=1; image[9005]=1; image[9006]=1; image[9007]=2; image[9008]=1; image[9009]=1; image[9010]=1; image[9011]=1; image[9012]=2; image[9013]=2; image[9014]=1; image[9015]=1; image[9016]=1; image[9017]=1; image[9018]=1; image[9019]=1; image[9020]=1; image[9021]=1; image[9022]=5; image[9023]=11; image[9024]=8; image[9025]=7; image[9026]=8; image[9027]=9; image[9028]=8; image[9029]=10; image[9030]=19; image[9031]=26; image[9032]=31; image[9033]=28; image[9034]=29; image[9035]=25; image[9036]=21; image[9037]=20; image[9038]=17; image[9039]=13; image[9040]=10; image[9041]=8; image[9042]=6; image[9043]=5; image[9044]=8; image[9045]=7; image[9046]=22; image[9047]=59; image[9048]=48; image[9049]=32; image[9050]=33; image[9051]=38; image[9052]=37; image[9053]=41; image[9054]=41; image[9055]=79; image[9056]=144; image[9057]=120; image[9058]=57; image[9059]=13; image[9060]=3; image[9061]=0; image[9062]=0; image[9063]=16; image[9064]=64; image[9065]=104; image[9066]=122; image[9067]=127; image[9068]=172; image[9069]=176; image[9070]=149; image[9071]=187; image[9072]=209; image[9073]=246; image[9074]=253; image[9075]=246; image[9076]=254; image[9077]=255; image[9078]=255; image[9079]=255; image[9080]=255; image[9081]=255; image[9082]=255; image[9083]=255; image[9084]=255; image[9085]=255; image[9086]=254; image[9087]=254; image[9088]=252; image[9089]=254; image[9090]=255; image[9091]=255; image[9092]=255; image[9093]=255; image[9094]=255; image[9095]=255; image[9096]=255; image[9097]=255; image[9098]=255; image[9099]=255; image[9100]=255; image[9101]=255; image[9102]=255; image[9103]=255; image[9104]=255; image[9105]=255; image[9106]=255; image[9107]=255; image[9108]=255; image[9109]=255; image[9110]=255; image[9111]=204; image[9112]=76; image[9113]=101; image[9114]=16; image[9115]=3; image[9116]=1; image[9117]=1; image[9118]=1; image[9119]=1; image[9120]=1; image[9121]=1; image[9122]=1; image[9123]=1; image[9124]=1; image[9125]=1; image[9126]=1; image[9127]=1; image[9128]=1; image[9129]=1; image[9130]=1; image[9131]=1; image[9132]=1; image[9133]=1; image[9134]=1; image[9135]=1; image[9136]=1; image[9137]=1; image[9138]=1; image[9139]=1; image[9140]=1; image[9141]=1; image[9142]=1; image[9143]=1; image[9144]=1; image[9145]=1; image[9146]=1; image[9147]=1; image[9148]=1; image[9149]=1; image[9150]=1; image[9151]=1; image[9152]=1; image[9153]=1; image[9154]=1; image[9155]=1; image[9156]=1; image[9157]=1; image[9158]=1; image[9159]=1; image[9160]=1; image[9161]=1; image[9162]=1; image[9163]=1; image[9164]=1; image[9165]=1; image[9166]=1; image[9167]=1; image[9168]=1; image[9169]=1; image[9170]=1; image[9171]=1; image[9172]=1; image[9173]=1; image[9174]=1; image[9175]=1; image[9176]=1; image[9177]=1; image[9178]=1; image[9179]=1; image[9180]=1; image[9181]=1; image[9182]=1; image[9183]=1; image[9184]=1; image[9185]=1; image[9186]=1; image[9187]=1; image[9188]=1; image[9189]=1; image[9190]=1; image[9191]=1; image[9192]=1; image[9193]=1; image[9194]=1; image[9195]=1; image[9196]=1; image[9197]=1; image[9198]=1; image[9199]=1; image[9200]=1; image[9201]=1; image[9202]=1; image[9203]=1; image[9204]=1; image[9205]=1; image[9206]=1; image[9207]=1; image[9208]=1; image[9209]=1; image[9210]=1; image[9211]=1; image[9212]=1; image[9213]=1; image[9214]=1; image[9215]=1; image[9216]=1; image[9217]=1; image[9218]=1; image[9219]=1; image[9220]=1; image[9221]=2; image[9222]=11; image[9223]=11; image[9224]=7; image[9225]=9; image[9226]=10; image[9227]=9; image[9228]=10; image[9229]=15; image[9230]=19; image[9231]=21; image[9232]=23; image[9233]=22; image[9234]=20; image[9235]=16; image[9236]=13; image[9237]=9; image[9238]=12; image[9239]=14; image[9240]=22; image[9241]=25; image[9242]=33; image[9243]=19; image[9244]=9; image[9245]=9; image[9246]=56; image[9247]=65; image[9248]=34; image[9249]=34; image[9250]=35; image[9251]=40; image[9252]=42; image[9253]=47; image[9254]=59; image[9255]=129; image[9256]=138; image[9257]=94; image[9258]=28; image[9259]=7; image[9260]=7; image[9261]=5; image[9262]=7; image[9263]=19; image[9264]=39; image[9265]=58; image[9266]=63; image[9267]=96; image[9268]=131; image[9269]=136; image[9270]=171; image[9271]=174; image[9272]=211; image[9273]=232; image[9274]=174; image[9275]=173; image[9276]=215; image[9277]=241; image[9278]=249; image[9279]=255; image[9280]=255; image[9281]=247; image[9282]=248; image[9283]=254; image[9284]=244; image[9285]=249; image[9286]=253; image[9287]=229; image[9288]=235; image[9289]=255; image[9290]=255; image[9291]=255; image[9292]=255; image[9293]=255; image[9294]=255; image[9295]=255; image[9296]=255; image[9297]=255; image[9298]=255; image[9299]=255; image[9300]=255; image[9301]=255; image[9302]=255; image[9303]=255; image[9304]=255; image[9305]=255; image[9306]=255; image[9307]=255; image[9308]=255; image[9309]=255; image[9310]=212; image[9311]=67; image[9312]=99; image[9313]=20; image[9314]=3; image[9315]=1; image[9316]=1; image[9317]=1; image[9318]=1; image[9319]=1; image[9320]=1; image[9321]=1; image[9322]=1; image[9323]=1; image[9324]=1; image[9325]=1; image[9326]=1; image[9327]=1; image[9328]=1; image[9329]=1; image[9330]=1; image[9331]=1; image[9332]=1; image[9333]=1; image[9334]=1; image[9335]=1; image[9336]=1; image[9337]=1; image[9338]=1; image[9339]=1; image[9340]=1; image[9341]=1; image[9342]=1; image[9343]=1; image[9344]=1; image[9345]=1; image[9346]=1; image[9347]=1; image[9348]=1; image[9349]=1; image[9350]=1; image[9351]=1; image[9352]=1; image[9353]=1; image[9354]=1; image[9355]=1; image[9356]=1; image[9357]=1; image[9358]=1; image[9359]=1; image[9360]=1; image[9361]=1; image[9362]=1; image[9363]=1; image[9364]=1; image[9365]=1; image[9366]=1; image[9367]=1; image[9368]=1; image[9369]=1; image[9370]=1; image[9371]=1; image[9372]=1; image[9373]=1; image[9374]=1; image[9375]=1; image[9376]=1; image[9377]=1; image[9378]=1; image[9379]=1; image[9380]=1; image[9381]=1; image[9382]=1; image[9383]=1; image[9384]=1; image[9385]=1; image[9386]=1; image[9387]=1; image[9388]=1; image[9389]=1; image[9390]=1; image[9391]=1; image[9392]=1; image[9393]=1; image[9394]=1; image[9395]=1; image[9396]=1; image[9397]=1; image[9398]=1; image[9399]=1; image[9400]=1; image[9401]=1; image[9402]=1; image[9403]=1; image[9404]=1; image[9405]=1; image[9406]=1; image[9407]=1; image[9408]=1; image[9409]=1; image[9410]=1; image[9411]=1; image[9412]=1; image[9413]=1; image[9414]=1; image[9415]=1; image[9416]=1; image[9417]=1; image[9418]=1; image[9419]=1; image[9420]=1; image[9421]=10; image[9422]=13; image[9423]=8; image[9424]=10; image[9425]=9; image[9426]=9; image[9427]=8; image[9428]=8; image[9429]=14; image[9430]=15; image[9431]=18; image[9432]=16; image[9433]=12; image[9434]=8; image[9435]=9; image[9436]=16; image[9437]=33; image[9438]=40; image[9439]=45; image[9440]=51; image[9441]=51; image[9442]=14; image[9443]=6; image[9444]=4; image[9445]=48; image[9446]=83; image[9447]=41; image[9448]=35; image[9449]=35; image[9450]=47; image[9451]=47; image[9452]=54; image[9453]=46; image[9454]=91; image[9455]=140; image[9456]=147; image[9457]=79; image[9458]=17; image[9459]=21; image[9460]=29; image[9461]=25; image[9462]=34; image[9463]=38; image[9464]=48; image[9465]=50; image[9466]=69; image[9467]=98; image[9468]=132; image[9469]=150; image[9470]=177; image[9471]=200; image[9472]=215; image[9473]=162; image[9474]=104; image[9475]=119; image[9476]=170; image[9477]=197; image[9478]=216; image[9479]=229; image[9480]=189; image[9481]=190; image[9482]=214; image[9483]=162; image[9484]=199; image[9485]=255; image[9486]=253; image[9487]=239; image[9488]=255; image[9489]=255; image[9490]=255; image[9491]=255; image[9492]=255; image[9493]=255; image[9494]=255; image[9495]=255; image[9496]=255; image[9497]=255; image[9498]=255; image[9499]=255; image[9500]=255; image[9501]=255; image[9502]=255; image[9503]=255; image[9504]=255; image[9505]=255; image[9506]=255; image[9507]=255; image[9508]=255; image[9509]=247; image[9510]=61; image[9511]=87; image[9512]=25; image[9513]=4; image[9514]=1; image[9515]=1; image[9516]=1; image[9517]=1; image[9518]=1; image[9519]=1; image[9520]=1; image[9521]=1; image[9522]=1; image[9523]=1; image[9524]=1; image[9525]=1; image[9526]=1; image[9527]=1; image[9528]=1; image[9529]=1; image[9530]=1; image[9531]=1; image[9532]=1; image[9533]=1; image[9534]=1; image[9535]=1; image[9536]=1; image[9537]=1; image[9538]=1; image[9539]=1; image[9540]=1; image[9541]=1; image[9542]=1; image[9543]=1; image[9544]=1; image[9545]=1; image[9546]=1; image[9547]=1; image[9548]=1; image[9549]=1; image[9550]=1; image[9551]=1; image[9552]=1; image[9553]=1; image[9554]=1; image[9555]=1; image[9556]=1; image[9557]=1; image[9558]=1; image[9559]=1; image[9560]=1; image[9561]=1; image[9562]=1; image[9563]=1; image[9564]=1; image[9565]=1; image[9566]=1; image[9567]=1; image[9568]=1; image[9569]=1; image[9570]=1; image[9571]=1; image[9572]=1; image[9573]=1; image[9574]=1; image[9575]=1; image[9576]=1; image[9577]=1; image[9578]=1; image[9579]=1; image[9580]=1; image[9581]=1; image[9582]=1; image[9583]=1; image[9584]=1; image[9585]=1; image[9586]=1; image[9587]=1; image[9588]=1; image[9589]=1; image[9590]=1; image[9591]=1; image[9592]=1; image[9593]=1; image[9594]=1; image[9595]=1; image[9596]=1; image[9597]=1; image[9598]=1; image[9599]=1; image[9600]=1; image[9601]=1; image[9602]=1; image[9603]=1; image[9604]=1; image[9605]=1; image[9606]=1; image[9607]=1; image[9608]=1; image[9609]=1; image[9610]=1; image[9611]=2; image[9612]=1; image[9613]=1; image[9614]=1; image[9615]=1; image[9616]=1; image[9617]=1; image[9618]=1; image[9619]=1; image[9620]=5; image[9621]=10; image[9622]=8; image[9623]=8; image[9624]=10; image[9625]=9; image[9626]=6; image[9627]=8; image[9628]=16; image[9629]=15; image[9630]=11; image[9631]=9; image[9632]=10; image[9633]=22; image[9634]=38; image[9635]=38; image[9636]=33; image[9637]=38; image[9638]=43; image[9639]=30; image[9640]=14; image[9641]=8; image[9642]=12; image[9643]=17; image[9644]=22; image[9645]=58; image[9646]=63; image[9647]=43; image[9648]=40; image[9649]=42; image[9650]=42; image[9651]=40; image[9652]=42; image[9653]=45; image[9654]=115; image[9655]=172; image[9656]=166; image[9657]=76; image[9658]=22; image[9659]=63; image[9660]=83; image[9661]=87; image[9662]=82; image[9663]=72; image[9664]=61; image[9665]=61; image[9666]=70; image[9667]=102; image[9668]=127; image[9669]=167; image[9670]=210; image[9671]=233; image[9672]=221; image[9673]=154; image[9674]=146; image[9675]=179; image[9676]=172; image[9677]=151; image[9678]=173; image[9679]=151; image[9680]=103; image[9681]=79; image[9682]=56; image[9683]=43; image[9684]=69; image[9685]=189; image[9686]=252; image[9687]=255; image[9688]=255; image[9689]=255; image[9690]=255; image[9691]=255; image[9692]=255; image[9693]=255; image[9694]=255; image[9695]=255; image[9696]=255; image[9697]=255; image[9698]=255; image[9699]=255; image[9700]=255; image[9701]=255; image[9702]=255; image[9703]=255; image[9704]=255; image[9705]=255; image[9706]=255; image[9707]=255; image[9708]=255; image[9709]=66; image[9710]=89; image[9711]=42; image[9712]=5; image[9713]=1; image[9714]=1; image[9715]=1; image[9716]=1; image[9717]=1; image[9718]=1; image[9719]=1; image[9720]=1; image[9721]=1; image[9722]=1; image[9723]=1; image[9724]=1; image[9725]=1; image[9726]=1; image[9727]=1; image[9728]=1; image[9729]=1; image[9730]=1; image[9731]=1; image[9732]=1; image[9733]=1; image[9734]=1; image[9735]=1; image[9736]=1; image[9737]=1; image[9738]=1; image[9739]=1; image[9740]=1; image[9741]=1; image[9742]=1; image[9743]=1; image[9744]=1; image[9745]=1; image[9746]=1; image[9747]=1; image[9748]=1; image[9749]=1; image[9750]=1; image[9751]=1; image[9752]=1; image[9753]=1; image[9754]=1; image[9755]=1; image[9756]=1; image[9757]=1; image[9758]=1; image[9759]=1; image[9760]=1; image[9761]=1; image[9762]=1; image[9763]=1; image[9764]=1; image[9765]=1; image[9766]=1; image[9767]=1; image[9768]=1; image[9769]=1; image[9770]=1; image[9771]=1; image[9772]=1; image[9773]=1; image[9774]=1; image[9775]=1; image[9776]=1; image[9777]=1; image[9778]=1; image[9779]=1; image[9780]=1; image[9781]=1; image[9782]=1; image[9783]=1; image[9784]=1; image[9785]=1; image[9786]=1; image[9787]=1; image[9788]=1; image[9789]=1; image[9790]=1; image[9791]=1; image[9792]=1; image[9793]=1; image[9794]=1; image[9795]=1; image[9796]=1; image[9797]=1; image[9798]=1; image[9799]=1; image[9800]=1; image[9801]=1; image[9802]=1; image[9803]=1; image[9804]=1; image[9805]=1; image[9806]=1; image[9807]=1; image[9808]=1; image[9809]=1; image[9810]=2; image[9811]=1; image[9812]=1; image[9813]=1; image[9814]=1; image[9815]=1; image[9816]=1; image[9817]=1; image[9818]=1; image[9819]=3; image[9820]=9; image[9821]=9; image[9822]=7; image[9823]=9; image[9824]=9; image[9825]=9; image[9826]=8; image[9827]=10; image[9828]=8; image[9829]=4; image[9830]=12; image[9831]=22; image[9832]=32; image[9833]=41; image[9834]=36; image[9835]=33; image[9836]=38; image[9837]=26; image[9838]=14; image[9839]=9; image[9840]=16; image[9841]=20; image[9842]=25; image[9843]=18; image[9844]=41; image[9845]=80; image[9846]=48; image[9847]=34; image[9848]=39; image[9849]=43; image[9850]=40; image[9851]=44; image[9852]=40; image[9853]=87; image[9854]=154; image[9855]=170; image[9856]=112; image[9857]=26; image[9858]=37; image[9859]=75; image[9860]=98; image[9861]=91; image[9862]=82; image[9863]=84; image[9864]=81; image[9865]=74; image[9866]=89; image[9867]=116; image[9868]=137; image[9869]=185; image[9870]=230; image[9871]=231; image[9872]=185; image[9873]=160; image[9874]=166; image[9875]=155; image[9876]=138; image[9877]=147; image[9878]=141; image[9879]=107; image[9880]=79; image[9881]=86; image[9882]=77; image[9883]=39; image[9884]=78; image[9885]=202; image[9886]=254; image[9887]=254; image[9888]=255; image[9889]=255; image[9890]=255; image[9891]=255; image[9892]=255; image[9893]=255; image[9894]=255; image[9895]=255; image[9896]=255; image[9897]=255; image[9898]=255; image[9899]=255; image[9900]=255; image[9901]=255; image[9902]=255; image[9903]=255; image[9904]=255; image[9905]=255; image[9906]=255; image[9907]=255; image[9908]=86; image[9909]=90; image[9910]=48; image[9911]=6; image[9912]=1; image[9913]=1; image[9914]=1; image[9915]=1; image[9916]=1; image[9917]=1; image[9918]=1; image[9919]=1; image[9920]=1; image[9921]=1; image[9922]=1; image[9923]=1; image[9924]=1; image[9925]=1; image[9926]=1; image[9927]=1; image[9928]=1; image[9929]=1; image[9930]=1; image[9931]=1; image[9932]=1; image[9933]=1; image[9934]=1; image[9935]=1; image[9936]=1; image[9937]=1; image[9938]=1; image[9939]=1; image[9940]=1; image[9941]=1; image[9942]=1; image[9943]=1; image[9944]=1; image[9945]=1; image[9946]=1; image[9947]=1; image[9948]=1; image[9949]=1; image[9950]=1; image[9951]=1; image[9952]=1; image[9953]=1; image[9954]=1; image[9955]=1; image[9956]=1; image[9957]=1; image[9958]=1; image[9959]=1; image[9960]=1; image[9961]=1; image[9962]=1; image[9963]=1; image[9964]=1; image[9965]=1; image[9966]=1; image[9967]=1; image[9968]=1; image[9969]=1; image[9970]=1; image[9971]=1; image[9972]=1; image[9973]=1; image[9974]=1; image[9975]=1; image[9976]=1; image[9977]=1; image[9978]=1; image[9979]=1; image[9980]=1; image[9981]=1; image[9982]=1; image[9983]=1; image[9984]=1; image[9985]=1; image[9986]=1; image[9987]=1; image[9988]=1; image[9989]=1; image[9990]=1; image[9991]=1; image[9992]=1; image[9993]=0; image[9994]=1; image[9995]=1; image[9996]=1; image[9997]=1; image[9998]=1; image[9999]=1; image[10000]=1; image[10001]=1; image[10002]=1; image[10003]=1; image[10004]=1; image[10005]=1; image[10006]=1; image[10007]=2; image[10008]=3; image[10009]=3; image[10010]=2; image[10011]=1; image[10012]=1; image[10013]=1; image[10014]=1; image[10015]=1; image[10016]=1; image[10017]=1; image[10018]=2; image[10019]=7; image[10020]=10; image[10021]=9; image[10022]=11; image[10023]=12; image[10024]=12; image[10025]=8; image[10026]=3; image[10027]=4; image[10028]=9; image[10029]=25; image[10030]=37; image[10031]=37; image[10032]=38; image[10033]=37; image[10034]=18; image[10035]=11; image[10036]=13; image[10037]=21; image[10038]=30; image[10039]=44; image[10040]=36; image[10041]=29; image[10042]=21; image[10043]=21; image[10044]=82; image[10045]=60; image[10046]=33; image[10047]=36; image[10048]=38; image[10049]=41; image[10050]=50; image[10051]=49; image[10052]=46; image[10053]=103; image[10054]=145; image[10055]=142; image[10056]=85; image[10057]=25; image[10058]=30; image[10059]=73; image[10060]=88; image[10061]=82; image[10062]=105; image[10063]=96; image[10064]=79; image[10065]=78; image[10066]=79; image[10067]=93; image[10068]=106; image[10069]=131; image[10070]=170; image[10071]=195; image[10072]=170; image[10073]=145; image[10074]=144; image[10075]=124; image[10076]=111; image[10077]=113; image[10078]=103; image[10079]=94; image[10080]=107; image[10081]=144; image[10082]=89; image[10083]=41; image[10084]=110; image[10085]=230; image[10086]=253; image[10087]=255; image[10088]=255; image[10089]=255; image[10090]=255; image[10091]=255; image[10092]=255; image[10093]=255; image[10094]=255; image[10095]=255; image[10096]=255; image[10097]=255; image[10098]=255; image[10099]=255; image[10100]=255; image[10101]=255; image[10102]=255; image[10103]=255; image[10104]=255; image[10105]=255; image[10106]=255; image[10107]=98; image[10108]=81; image[10109]=56; image[10110]=7; image[10111]=1; image[10112]=1; image[10113]=1; image[10114]=1; image[10115]=1; image[10116]=1; image[10117]=1; image[10118]=1; image[10119]=1; image[10120]=1; image[10121]=1; image[10122]=1; image[10123]=1; image[10124]=1; image[10125]=1; image[10126]=1; image[10127]=1; image[10128]=1; image[10129]=1; image[10130]=1; image[10131]=1; image[10132]=1; image[10133]=1; image[10134]=1; image[10135]=1; image[10136]=1; image[10137]=1; image[10138]=1; image[10139]=1; image[10140]=1; image[10141]=1; image[10142]=1; image[10143]=1; image[10144]=1; image[10145]=1; image[10146]=1; image[10147]=1; image[10148]=1; image[10149]=1; image[10150]=1; image[10151]=1; image[10152]=1; image[10153]=1; image[10154]=1; image[10155]=1; image[10156]=1; image[10157]=1; image[10158]=1; image[10159]=1; image[10160]=1; image[10161]=1; image[10162]=1; image[10163]=1; image[10164]=1; image[10165]=1; image[10166]=1; image[10167]=1; image[10168]=1; image[10169]=1; image[10170]=1; image[10171]=1; image[10172]=1; image[10173]=1; image[10174]=1; image[10175]=1; image[10176]=1; image[10177]=1; image[10178]=1; image[10179]=1; image[10180]=1; image[10181]=1; image[10182]=1; image[10183]=1; image[10184]=1; image[10185]=1; image[10186]=1; image[10187]=1; image[10188]=1; image[10189]=1; image[10190]=1; image[10191]=1; image[10192]=1; image[10193]=1; image[10194]=1; image[10195]=1; image[10196]=1; image[10197]=1; image[10198]=1; image[10199]=1; image[10200]=1; image[10201]=1; image[10202]=1; image[10203]=1; image[10204]=1; image[10205]=1; image[10206]=2; image[10207]=2; image[10208]=2; image[10209]=1; image[10210]=1; image[10211]=1; image[10212]=1; image[10213]=1; image[10214]=1; image[10215]=1; image[10216]=1; image[10217]=1; image[10218]=4; image[10219]=12; image[10220]=9; image[10221]=9; image[10222]=11; image[10223]=11; image[10224]=11; image[10225]=6; image[10226]=5; image[10227]=9; image[10228]=15; image[10229]=22; image[10230]=22; image[10231]=17; image[10232]=16; image[10233]=17; image[10234]=23; image[10235]=35; image[10236]=36; image[10237]=35; image[10238]=35; image[10239]=36; image[10240]=32; image[10241]=29; image[10242]=21; image[10243]=61; image[10244]=66; image[10245]=42; image[10246]=38; image[10247]=41; image[10248]=45; image[10249]=45; image[10250]=49; image[10251]=43; image[10252]=63; image[10253]=135; image[10254]=153; image[10255]=113; image[10256]=54; image[10257]=23; image[10258]=34; image[10259]=70; image[10260]=80; image[10261]=98; image[10262]=98; image[10263]=88; image[10264]=78; image[10265]=70; image[10266]=77; image[10267]=76; image[10268]=87; image[10269]=126; image[10270]=145; image[10271]=161; image[10272]=142; image[10273]=142; image[10274]=130; image[10275]=112; image[10276]=123; image[10277]=122; image[10278]=110; image[10279]=109; image[10280]=138; image[10281]=133; image[10282]=64; image[10283]=83; image[10284]=208; image[10285]=253; image[10286]=255; image[10287]=255; image[10288]=255; image[10289]=255; image[10290]=255; image[10291]=255; image[10292]=255; image[10293]=255; image[10294]=255; image[10295]=255; image[10296]=255; image[10297]=255; image[10298]=255; image[10299]=255; image[10300]=255; image[10301]=255; image[10302]=255; image[10303]=255; image[10304]=255; image[10305]=255; image[10306]=102; image[10307]=63; image[10308]=54; image[10309]=6; image[10310]=1; image[10311]=1; image[10312]=1; image[10313]=1; image[10314]=1; image[10315]=1; image[10316]=1; image[10317]=1; image[10318]=1; image[10319]=1; image[10320]=1; image[10321]=1; image[10322]=1; image[10323]=1; image[10324]=1; image[10325]=1; image[10326]=1; image[10327]=1; image[10328]=1; image[10329]=1; image[10330]=1; image[10331]=1; image[10332]=1; image[10333]=1; image[10334]=1; image[10335]=1; image[10336]=1; image[10337]=1; image[10338]=1; image[10339]=1; image[10340]=1; image[10341]=1; image[10342]=1; image[10343]=1; image[10344]=1; image[10345]=1; image[10346]=1; image[10347]=1; image[10348]=1; image[10349]=1; image[10350]=1; image[10351]=1; image[10352]=1; image[10353]=1; image[10354]=1; image[10355]=1; image[10356]=1; image[10357]=1; image[10358]=1; image[10359]=1; image[10360]=1; image[10361]=1; image[10362]=1; image[10363]=1; image[10364]=1; image[10365]=1; image[10366]=1; image[10367]=1; image[10368]=1; image[10369]=1; image[10370]=1; image[10371]=1; image[10372]=1; image[10373]=1; image[10374]=1; image[10375]=1; image[10376]=1; image[10377]=1; image[10378]=1; image[10379]=1; image[10380]=1; image[10381]=1; image[10382]=1; image[10383]=1; image[10384]=1; image[10385]=1; image[10386]=1; image[10387]=1; image[10388]=1; image[10389]=1; image[10390]=1; image[10391]=1; image[10392]=1; image[10393]=1; image[10394]=1; image[10395]=1; image[10396]=1; image[10397]=1; image[10398]=1; image[10399]=1; image[10400]=1; image[10401]=1; image[10402]=1; image[10403]=1; image[10404]=2; image[10405]=2; image[10406]=3; image[10407]=3; image[10408]=1; image[10409]=1; image[10410]=1; image[10411]=1; image[10412]=1; image[10413]=1; image[10414]=1; image[10415]=1; image[10416]=1; image[10417]=3; image[10418]=13; image[10419]=8; image[10420]=6; image[10421]=9; image[10422]=11; image[10423]=13; image[10424]=6; image[10425]=3; image[10426]=4; image[10427]=4; image[10428]=6; image[10429]=7; image[10430]=9; image[10431]=19; image[10432]=29; image[10433]=29; image[10434]=29; image[10435]=31; image[10436]=35; image[10437]=34; image[10438]=41; image[10439]=46; image[10440]=35; image[10441]=24; image[10442]=40; image[10443]=68; image[10444]=61; image[10445]=43; image[10446]=45; image[10447]=48; image[10448]=43; image[10449]=48; image[10450]=47; image[10451]=47; image[10452]=104; image[10453]=156; image[10454]=126; image[10455]=77; image[10456]=28; image[10457]=11; image[10458]=45; image[10459]=78; image[10460]=92; image[10461]=89; image[10462]=82; image[10463]=75; image[10464]=68; image[10465]=71; image[10466]=79; image[10467]=77; image[10468]=97; image[10469]=121; image[10470]=159; image[10471]=153; image[10472]=135; image[10473]=125; image[10474]=117; image[10475]=121; image[10476]=121; image[10477]=134; image[10478]=143; image[10479]=134; image[10480]=161; image[10481]=87; image[10482]=65; image[10483]=165; image[10484]=230; image[10485]=254; image[10486]=255; image[10487]=255; image[10488]=255; image[10489]=255; image[10490]=255; image[10491]=255; image[10492]=255; image[10493]=255; image[10494]=255; image[10495]=255; image[10496]=255; image[10497]=255; image[10498]=255; image[10499]=255; image[10500]=255; image[10501]=255; image[10502]=255; image[10503]=255; image[10504]=255; image[10505]=121; image[10506]=60; image[10507]=65; image[10508]=7; image[10509]=1; image[10510]=2; image[10511]=1; image[10512]=1; image[10513]=1; image[10514]=1; image[10515]=1; image[10516]=1; image[10517]=1; image[10518]=1; image[10519]=1; image[10520]=1; image[10521]=1; image[10522]=1; image[10523]=1; image[10524]=1; image[10525]=1; image[10526]=1; image[10527]=1; image[10528]=1; image[10529]=1; image[10530]=1; image[10531]=1; image[10532]=1; image[10533]=1; image[10534]=1; image[10535]=1; image[10536]=1; image[10537]=1; image[10538]=1; image[10539]=1; image[10540]=1; image[10541]=1; image[10542]=1; image[10543]=1; image[10544]=1; image[10545]=1; image[10546]=1; image[10547]=1; image[10548]=1; image[10549]=1; image[10550]=1; image[10551]=1; image[10552]=1; image[10553]=1; image[10554]=1; image[10555]=1; image[10556]=1; image[10557]=1; image[10558]=1; image[10559]=1; image[10560]=1; image[10561]=1; image[10562]=1; image[10563]=1; image[10564]=1; image[10565]=1; image[10566]=1; image[10567]=1; image[10568]=1; image[10569]=1; image[10570]=1; image[10571]=1; image[10572]=1; image[10573]=1; image[10574]=1; image[10575]=1; image[10576]=1; image[10577]=1; image[10578]=1; image[10579]=1; image[10580]=1; image[10581]=1; image[10582]=1; image[10583]=1; image[10584]=1; image[10585]=1; image[10586]=1; image[10587]=1; image[10588]=1; image[10589]=1; image[10590]=1; image[10591]=1; image[10592]=1; image[10593]=1; image[10594]=1; image[10595]=1; image[10596]=1; image[10597]=1; image[10598]=1; image[10599]=2; image[10600]=1; image[10601]=1; image[10602]=2; image[10603]=2; image[10604]=2; image[10605]=3; image[10606]=2; image[10607]=1; image[10608]=1; image[10609]=1; image[10610]=1; image[10611]=1; image[10612]=1; image[10613]=1; image[10614]=1; image[10615]=1; image[10616]=3; image[10617]=12; image[10618]=10; image[10619]=6; image[10620]=8; image[10621]=10; image[10622]=12; image[10623]=7; image[10624]=4; image[10625]=8; image[10626]=12; image[10627]=16; image[10628]=26; image[10629]=30; image[10630]=40; image[10631]=34; image[10632]=30; image[10633]=34; image[10634]=27; image[10635]=24; image[10636]=33; image[10637]=35; image[10638]=36; image[10639]=40; image[10640]=45; image[10641]=52; image[10642]=84; image[10643]=90; image[10644]=41; image[10645]=35; image[10646]=40; image[10647]=47; image[10648]=48; image[10649]=47; image[10650]=42; image[10651]=37; image[10652]=94; image[10653]=162; image[10654]=113; image[10655]=52; image[10656]=12; image[10657]=10; image[10658]=49; image[10659]=103; image[10660]=113; image[10661]=89; image[10662]=71; image[10663]=65; image[10664]=60; image[10665]=79; image[10666]=70; image[10667]=60; image[10668]=88; image[10669]=117; image[10670]=128; image[10671]=113; image[10672]=115; image[10673]=111; image[10674]=100; image[10675]=101; image[10676]=125; image[10677]=163; image[10678]=149; image[10679]=166; image[10680]=124; image[10681]=61; image[10682]=128; image[10683]=241; image[10684]=255; image[10685]=255; image[10686]=255; image[10687]=255; image[10688]=255; image[10689]=255; image[10690]=255; image[10691]=255; image[10692]=255; image[10693]=255; image[10694]=255; image[10695]=255; image[10696]=255; image[10697]=255; image[10698]=255; image[10699]=255; image[10700]=255; image[10701]=255; image[10702]=253; image[10703]=255; image[10704]=215; image[10705]=73; image[10706]=64; image[10707]=8; image[10708]=3; image[10709]=1; image[10710]=1; image[10711]=1; image[10712]=1; image[10713]=1; image[10714]=1; image[10715]=1; image[10716]=1; image[10717]=1; image[10718]=1; image[10719]=1; image[10720]=1; image[10721]=1; image[10722]=1; image[10723]=1; image[10724]=1; image[10725]=1; image[10726]=1; image[10727]=1; image[10728]=1; image[10729]=1; image[10730]=1; image[10731]=1; image[10732]=1; image[10733]=1; image[10734]=1; image[10735]=1; image[10736]=1; image[10737]=1; image[10738]=1; image[10739]=1; image[10740]=1; image[10741]=1; image[10742]=1; image[10743]=1; image[10744]=1; image[10745]=1; image[10746]=1; image[10747]=1; image[10748]=1; image[10749]=1; image[10750]=1; image[10751]=1; image[10752]=1; image[10753]=1; image[10754]=1; image[10755]=1; image[10756]=1; image[10757]=1; image[10758]=1; image[10759]=1; image[10760]=1; image[10761]=1; image[10762]=1; image[10763]=1; image[10764]=1; image[10765]=1; image[10766]=1; image[10767]=1; image[10768]=1; image[10769]=1; image[10770]=1; image[10771]=1; image[10772]=1; image[10773]=1; image[10774]=1; image[10775]=1; image[10776]=1; image[10777]=1; image[10778]=1; image[10779]=1; image[10780]=1; image[10781]=1; image[10782]=1; image[10783]=1; image[10784]=1; image[10785]=1; image[10786]=1; image[10787]=1; image[10788]=1; image[10789]=1; image[10790]=1; image[10791]=1; image[10792]=1; image[10793]=1; image[10794]=1; image[10795]=1; image[10796]=1; image[10797]=1; image[10798]=1; image[10799]=1; image[10800]=2; image[10801]=3; image[10802]=3; image[10803]=2; image[10804]=3; image[10805]=2; image[10806]=1; image[10807]=1; image[10808]=1; image[10809]=1; image[10810]=1; image[10811]=1; image[10812]=1; image[10813]=1; image[10814]=1; image[10815]=2; image[10816]=11; image[10817]=11; image[10818]=8; image[10819]=7; image[10820]=9; image[10821]=12; image[10822]=10; image[10823]=7; image[10824]=12; image[10825]=20; image[10826]=25; image[10827]=30; image[10828]=32; image[10829]=36; image[10830]=29; image[10831]=25; image[10832]=27; image[10833]=24; image[10834]=24; image[10835]=32; image[10836]=31; image[10837]=31; image[10838]=37; image[10839]=44; image[10840]=46; image[10841]=71; image[10842]=94; image[10843]=51; image[10844]=39; image[10845]=37; image[10846]=51; image[10847]=52; image[10848]=48; image[10849]=48; image[10850]=37; image[10851]=60; image[10852]=135; image[10853]=135; image[10854]=65; image[10855]=23; image[10856]=6; image[10857]=21; image[10858]=56; image[10859]=75; image[10860]=78; image[10861]=73; image[10862]=67; image[10863]=62; image[10864]=73; image[10865]=70; image[10866]=67; image[10867]=85; image[10868]=101; image[10869]=108; image[10870]=121; image[10871]=124; image[10872]=108; image[10873]=101; image[10874]=101; image[10875]=99; image[10876]=122; image[10877]=149; image[10878]=173; image[10879]=143; image[10880]=56; image[10881]=95; image[10882]=218; image[10883]=250; image[10884]=252; image[10885]=255; image[10886]=255; image[10887]=255; image[10888]=255; image[10889]=255; image[10890]=255; image[10891]=255; image[10892]=255; image[10893]=255; image[10894]=255; image[10895]=255; image[10896]=255; image[10897]=255; image[10898]=255; image[10899]=255; image[10900]=255; image[10901]=254; image[10902]=255; image[10903]=221; image[10904]=59; image[10905]=70; image[10906]=11; image[10907]=2; image[10908]=1; image[10909]=1; image[10910]=1; image[10911]=1; image[10912]=1; image[10913]=1; image[10914]=1; image[10915]=1; image[10916]=1; image[10917]=1; image[10918]=1; image[10919]=1; image[10920]=1; image[10921]=1; image[10922]=1; image[10923]=1; image[10924]=1; image[10925]=1; image[10926]=1; image[10927]=1; image[10928]=1; image[10929]=1; image[10930]=1; image[10931]=1; image[10932]=1; image[10933]=1; image[10934]=1; image[10935]=1; image[10936]=1; image[10937]=1; image[10938]=1; image[10939]=1; image[10940]=1; image[10941]=1; image[10942]=1; image[10943]=1; image[10944]=1; image[10945]=1; image[10946]=1; image[10947]=1; image[10948]=1; image[10949]=1; image[10950]=1; image[10951]=1; image[10952]=1; image[10953]=1; image[10954]=1; image[10955]=1; image[10956]=1; image[10957]=1; image[10958]=1; image[10959]=1; image[10960]=1; image[10961]=1; image[10962]=1; image[10963]=1; image[10964]=1; image[10965]=1; image[10966]=1; image[10967]=1; image[10968]=1; image[10969]=1; image[10970]=1; image[10971]=1; image[10972]=1; image[10973]=1; image[10974]=1; image[10975]=1; image[10976]=1; image[10977]=1; image[10978]=1; image[10979]=1; image[10980]=1; image[10981]=1; image[10982]=1; image[10983]=1; image[10984]=1; image[10985]=1; image[10986]=1; image[10987]=1; image[10988]=1; image[10989]=1; image[10990]=1; image[10991]=1; image[10992]=1; image[10993]=1; image[10994]=1; image[10995]=1; image[10996]=1; image[10997]=1; image[10998]=1; image[10999]=2; image[11000]=4; image[11001]=3; image[11002]=2; image[11003]=2; image[11004]=2; image[11005]=1; image[11006]=1; image[11007]=1; image[11008]=1; image[11009]=1; image[11010]=1; image[11011]=1; image[11012]=1; image[11013]=1; image[11014]=2; image[11015]=9; image[11016]=12; image[11017]=8; image[11018]=7; image[11019]=9; image[11020]=12; image[11021]=12; image[11022]=9; image[11023]=8; image[11024]=18; image[11025]=23; image[11026]=21; image[11027]=25; image[11028]=27; image[11029]=27; image[11030]=27; image[11031]=26; image[11032]=27; image[11033]=31; image[11034]=33; image[11035]=30; image[11036]=31; image[11037]=40; image[11038]=45; image[11039]=31; image[11040]=47; image[11041]=82; image[11042]=66; image[11043]=45; image[11044]=32; image[11045]=49; image[11046]=55; image[11047]=51; image[11048]=49; image[11049]=43; image[11050]=40; image[11051]=80; image[11052]=145; image[11053]=90; image[11054]=39; image[11055]=9; image[11056]=10; image[11057]=38; image[11058]=57; image[11059]=41; image[11060]=41; image[11061]=48; image[11062]=58; image[11063]=65; image[11064]=84; image[11065]=79; image[11066]=68; image[11067]=83; image[11068]=91; image[11069]=133; image[11070]=152; image[11071]=113; image[11072]=94; image[11073]=104; image[11074]=105; image[11075]=100; image[11076]=136; image[11077]=177; image[11078]=150; image[11079]=48; image[11080]=62; image[11081]=165; image[11082]=242; image[11083]=254; image[11084]=255; image[11085]=255; image[11086]=255; image[11087]=255; image[11088]=255; image[11089]=255; image[11090]=255; image[11091]=255; image[11092]=255; image[11093]=255; image[11094]=255; image[11095]=255; image[11096]=255; image[11097]=255; image[11098]=255; image[11099]=255; image[11100]=251; image[11101]=253; image[11102]=243; image[11103]=42; image[11104]=75; image[11105]=15; image[11106]=2; image[11107]=2; image[11108]=1; image[11109]=1; image[11110]=1; image[11111]=1; image[11112]=1; image[11113]=1; image[11114]=1; image[11115]=1; image[11116]=1; image[11117]=1; image[11118]=1; image[11119]=1; image[11120]=1; image[11121]=1; image[11122]=1; image[11123]=1; image[11124]=1; image[11125]=1; image[11126]=1; image[11127]=1; image[11128]=1; image[11129]=1; image[11130]=1; image[11131]=1; image[11132]=1; image[11133]=1; image[11134]=1; image[11135]=1; image[11136]=1; image[11137]=1; image[11138]=1; image[11139]=1; image[11140]=1; image[11141]=1; image[11142]=1; image[11143]=1; image[11144]=1; image[11145]=1; image[11146]=1; image[11147]=1; image[11148]=1; image[11149]=1; image[11150]=1; image[11151]=1; image[11152]=0; image[11153]=1; image[11154]=1; image[11155]=1; image[11156]=1; image[11157]=1; image[11158]=1; image[11159]=1; image[11160]=1; image[11161]=1; image[11162]=1; image[11163]=1; image[11164]=1; image[11165]=1; image[11166]=1; image[11167]=1; image[11168]=1; image[11169]=1; image[11170]=1; image[11171]=1; image[11172]=1; image[11173]=1; image[11174]=1; image[11175]=1; image[11176]=1; image[11177]=1; image[11178]=1; image[11179]=1; image[11180]=1; image[11181]=1; image[11182]=1; image[11183]=1; image[11184]=1; image[11185]=1; image[11186]=1; image[11187]=1; image[11188]=1; image[11189]=1; image[11190]=1; image[11191]=1; image[11192]=1; image[11193]=1; image[11194]=1; image[11195]=1; image[11196]=1; image[11197]=1; image[11198]=2; image[11199]=3; image[11200]=2; image[11201]=1; image[11202]=1; image[11203]=2; image[11204]=1; image[11205]=1; image[11206]=1; image[11207]=1; image[11208]=1; image[11209]=1; image[11210]=1; image[11211]=1; image[11212]=1; image[11213]=2; image[11214]=8; image[11215]=11; image[11216]=11; image[11217]=7; image[11218]=8; image[11219]=10; image[11220]=12; image[11221]=11; image[11222]=8; image[11223]=11; image[11224]=19; image[11225]=23; image[11226]=26; image[11227]=25; image[11228]=28; image[11229]=29; image[11230]=31; image[11231]=32; image[11232]=30; image[11233]=30; image[11234]=32; image[11235]=36; image[11236]=39; image[11237]=38; image[11238]=26; image[11239]=30; image[11240]=52; image[11241]=90; image[11242]=60; image[11243]=32; image[11244]=42; image[11245]=47; image[11246]=49; image[11247]=48; image[11248]=49; image[11249]=45; image[11250]=36; image[11251]=104; image[11252]=142; image[11253]=76; image[11254]=29; image[11255]=9; image[11256]=17; image[11257]=85; image[11258]=116; image[11259]=97; image[11260]=72; image[11261]=60; image[11262]=61; image[11263]=81; image[11264]=81; image[11265]=80; image[11266]=106; image[11267]=131; image[11268]=115; image[11269]=118; image[11270]=115; image[11271]=106; image[11272]=100; image[11273]=109; image[11274]=115; image[11275]=144; image[11276]=189; image[11277]=169; image[11278]=60; image[11279]=112; image[11280]=241; image[11281]=255; image[11282]=255; image[11283]=255; image[11284]=255; image[11285]=255; image[11286]=255; image[11287]=255; image[11288]=255; image[11289]=255; image[11290]=255; image[11291]=255; image[11292]=255; image[11293]=255; image[11294]=255; image[11295]=255; image[11296]=255; image[11297]=255; image[11298]=255; image[11299]=248; image[11300]=252; image[11301]=229; image[11302]=39; image[11303]=67; image[11304]=15; image[11305]=2; image[11306]=2; image[11307]=1; image[11308]=1; image[11309]=1; image[11310]=1; image[11311]=1; image[11312]=1; image[11313]=1; image[11314]=1; image[11315]=1; image[11316]=1; image[11317]=1; image[11318]=1; image[11319]=1; image[11320]=1; image[11321]=1; image[11322]=1; image[11323]=1; image[11324]=1; image[11325]=1; image[11326]=1; image[11327]=1; image[11328]=1; image[11329]=1; image[11330]=1; image[11331]=1; image[11332]=1; image[11333]=1; image[11334]=1; image[11335]=1; image[11336]=1; image[11337]=1; image[11338]=1; image[11339]=1; image[11340]=1; image[11341]=1; image[11342]=1; image[11343]=1; image[11344]=1; image[11345]=1; image[11346]=1; image[11347]=1; image[11348]=1; image[11349]=1; image[11350]=1; image[11351]=1; image[11352]=1; image[11353]=1; image[11354]=1; image[11355]=1; image[11356]=1; image[11357]=1; image[11358]=1; image[11359]=1; image[11360]=1; image[11361]=1; image[11362]=1; image[11363]=1; image[11364]=1; image[11365]=1; image[11366]=1; image[11367]=1; image[11368]=1; image[11369]=1; image[11370]=1; image[11371]=1; image[11372]=1; image[11373]=1; image[11374]=1; image[11375]=1; image[11376]=1; image[11377]=1; image[11378]=1; image[11379]=1; image[11380]=1; image[11381]=1; image[11382]=1; image[11383]=1; image[11384]=1; image[11385]=1; image[11386]=1; image[11387]=1; image[11388]=1; image[11389]=1; image[11390]=1; image[11391]=1; image[11392]=1; image[11393]=1; image[11394]=1; image[11395]=1; image[11396]=1; image[11397]=1; image[11398]=2; image[11399]=2; image[11400]=1; image[11401]=1; image[11402]=1; image[11403]=1; image[11404]=1; image[11405]=1; image[11406]=1; image[11407]=1; image[11408]=1; image[11409]=1; image[11410]=1; image[11411]=1; image[11412]=1; image[11413]=7; image[11414]=11; image[11415]=12; image[11416]=7; image[11417]=8; image[11418]=8; image[11419]=10; image[11420]=10; image[11421]=10; image[11422]=9; image[11423]=14; image[11424]=22; image[11425]=25; image[11426]=29; image[11427]=31; image[11428]=27; image[11429]=23; image[11430]=26; image[11431]=28; image[11432]=30; image[11433]=32; image[11434]=35; image[11435]=39; image[11436]=37; image[11437]=40; image[11438]=32; image[11439]=32; image[11440]=89; image[11441]=75; image[11442]=32; image[11443]=38; image[11444]=43; image[11445]=45; image[11446]=47; image[11447]=45; image[11448]=44; image[11449]=34; image[11450]=71; image[11451]=134; image[11452]=101; image[11453]=43; image[11454]=14; image[11455]=11; image[11456]=53; image[11457]=118; image[11458]=150; image[11459]=120; image[11460]=71; image[11461]=55; image[11462]=57; image[11463]=73; image[11464]=94; image[11465]=107; image[11466]=130; image[11467]=113; image[11468]=113; image[11469]=122; image[11470]=134; image[11471]=125; image[11472]=128; image[11473]=131; image[11474]=163; image[11475]=211; image[11476]=178; image[11477]=74; image[11478]=164; image[11479]=255; image[11480]=255; image[11481]=233; image[11482]=228; image[11483]=253; image[11484]=255; image[11485]=255; image[11486]=255; image[11487]=255; image[11488]=255; image[11489]=255; image[11490]=255; image[11491]=255; image[11492]=255; image[11493]=255; image[11494]=255; image[11495]=255; image[11496]=255; image[11497]=255; image[11498]=242; image[11499]=243; image[11500]=236; image[11501]=48; image[11502]=60; image[11503]=15; image[11504]=2; image[11505]=1; image[11506]=1; image[11507]=1; image[11508]=1; image[11509]=1; image[11510]=1; image[11511]=1; image[11512]=1; image[11513]=1; image[11514]=1; image[11515]=1; image[11516]=1; image[11517]=1; image[11518]=1; image[11519]=1; image[11520]=1; image[11521]=1; image[11522]=1; image[11523]=1; image[11524]=1; image[11525]=1; image[11526]=1; image[11527]=1; image[11528]=1; image[11529]=1; image[11530]=1; image[11531]=1; image[11532]=1; image[11533]=1; image[11534]=1; image[11535]=1; image[11536]=1; image[11537]=1; image[11538]=1; image[11539]=1; image[11540]=1; image[11541]=1; image[11542]=1; image[11543]=1; image[11544]=1; image[11545]=1; image[11546]=1; image[11547]=1; image[11548]=1; image[11549]=1; image[11550]=1; image[11551]=1; image[11552]=1; image[11553]=1; image[11554]=1; image[11555]=1; image[11556]=1; image[11557]=1; image[11558]=1; image[11559]=1; image[11560]=1; image[11561]=1; image[11562]=1; image[11563]=1; image[11564]=1; image[11565]=1; image[11566]=1; image[11567]=1; image[11568]=1; image[11569]=1; image[11570]=1; image[11571]=1; image[11572]=1; image[11573]=1; image[11574]=1; image[11575]=1; image[11576]=1; image[11577]=1; image[11578]=1; image[11579]=1; image[11580]=1; image[11581]=1; image[11582]=1; image[11583]=1; image[11584]=1; image[11585]=1; image[11586]=1; image[11587]=1; image[11588]=1; image[11589]=1; image[11590]=1; image[11591]=1; image[11592]=1; image[11593]=1; image[11594]=1; image[11595]=1; image[11596]=1; image[11597]=3; image[11598]=3; image[11599]=2; image[11600]=2; image[11601]=1; image[11602]=1; image[11603]=1; image[11604]=1; image[11605]=1; image[11606]=1; image[11607]=1; image[11608]=1; image[11609]=1; image[11610]=1; image[11611]=1; image[11612]=5; image[11613]=10; image[11614]=12; image[11615]=6; image[11616]=7; image[11617]=8; image[11618]=11; image[11619]=10; image[11620]=11; image[11621]=7; image[11622]=7; image[11623]=19; image[11624]=21; image[11625]=27; image[11626]=35; image[11627]=33; image[11628]=30; image[11629]=34; image[11630]=35; image[11631]=32; image[11632]=31; image[11633]=32; image[11634]=34; image[11635]=33; image[11636]=43; image[11637]=36; image[11638]=17; image[11639]=54; image[11640]=84; image[11641]=46; image[11642]=32; image[11643]=42; image[11644]=51; image[11645]=54; image[11646]=50; image[11647]=45; image[11648]=43; image[11649]=41; image[11650]=92; image[11651]=141; image[11652]=77; image[11653]=22; image[11654]=15; image[11655]=35; image[11656]=93; image[11657]=169; image[11658]=220; image[11659]=157; image[11660]=62; image[11661]=39; image[11662]=78; image[11663]=89; image[11664]=77; image[11665]=92; image[11666]=109; image[11667]=138; image[11668]=126; image[11669]=142; image[11670]=186; image[11671]=222; image[11672]=188; image[11673]=204; image[11674]=255; image[11675]=230; image[11676]=150; image[11677]=234; image[11678]=255; image[11679]=255; image[11680]=178; image[11681]=136; image[11682]=225; image[11683]=255; image[11684]=255; image[11685]=255; image[11686]=255; image[11687]=255; image[11688]=255; image[11689]=255; image[11690]=255; image[11691]=255; image[11692]=255; image[11693]=255; image[11694]=255; image[11695]=255; image[11696]=255; image[11697]=203; image[11698]=196; image[11699]=240; image[11700]=47; image[11701]=65; image[11702]=16; image[11703]=2; image[11704]=1; image[11705]=1; image[11706]=1; image[11707]=1; image[11708]=1; image[11709]=1; image[11710]=1; image[11711]=1; image[11712]=1; image[11713]=1; image[11714]=1; image[11715]=1; image[11716]=1; image[11717]=1; image[11718]=1; image[11719]=1; image[11720]=1; image[11721]=1; image[11722]=1; image[11723]=1; image[11724]=1; image[11725]=1; image[11726]=1; image[11727]=1; image[11728]=1; image[11729]=1; image[11730]=1; image[11731]=1; image[11732]=1; image[11733]=1; image[11734]=1; image[11735]=1; image[11736]=1; image[11737]=1; image[11738]=1; image[11739]=1; image[11740]=1; image[11741]=1; image[11742]=1; image[11743]=1; image[11744]=1; image[11745]=1; image[11746]=1; image[11747]=1; image[11748]=1; image[11749]=1; image[11750]=1; image[11751]=1; image[11752]=1; image[11753]=1; image[11754]=1; image[11755]=1; image[11756]=1; image[11757]=1; image[11758]=1; image[11759]=1; image[11760]=1; image[11761]=1; image[11762]=1; image[11763]=1; image[11764]=1; image[11765]=1; image[11766]=1; image[11767]=1; image[11768]=1; image[11769]=1; image[11770]=1; image[11771]=1; image[11772]=1; image[11773]=1; image[11774]=1; image[11775]=1; image[11776]=1; image[11777]=1; image[11778]=1; image[11779]=1; image[11780]=1; image[11781]=1; image[11782]=1; image[11783]=1; image[11784]=1; image[11785]=1; image[11786]=1; image[11787]=1; image[11788]=1; image[11789]=1; image[11790]=1; image[11791]=1; image[11792]=1; image[11793]=1; image[11794]=1; image[11795]=1; image[11796]=2; image[11797]=2; image[11798]=2; image[11799]=2; image[11800]=1; image[11801]=1; image[11802]=1; image[11803]=1; image[11804]=1; image[11805]=1; image[11806]=1; image[11807]=1; image[11808]=1; image[11809]=1; image[11810]=1; image[11811]=4; image[11812]=8; image[11813]=13; image[11814]=9; image[11815]=7; image[11816]=8; image[11817]=11; image[11818]=10; image[11819]=11; image[11820]=9; image[11821]=6; image[11822]=17; image[11823]=20; image[11824]=22; image[11825]=27; image[11826]=26; image[11827]=29; image[11828]=33; image[11829]=33; image[11830]=31; image[11831]=33; image[11832]=31; image[11833]=27; image[11834]=27; image[11835]=30; image[11836]=31; image[11837]=23; image[11838]=21; image[11839]=50; image[11840]=70; image[11841]=32; image[11842]=36; image[11843]=47; image[11844]=57; image[11845]=59; image[11846]=49; image[11847]=48; image[11848]=42; image[11849]=54; image[11850]=96; image[11851]=99; image[11852]=46; image[11853]=19; image[11854]=34; image[11855]=118; image[11856]=235; image[11857]=253; image[11858]=243; image[11859]=210; image[11860]=155; image[11861]=125; image[11862]=139; image[11863]=134; image[11864]=110; image[11865]=97; image[11866]=138; image[11867]=184; image[11868]=211; image[11869]=237; image[11870]=254; image[11871]=246; image[11872]=244; image[11873]=255; image[11874]=254; image[11875]=242; image[11876]=254; image[11877]=255; image[11878]=255; image[11879]=158; image[11880]=108; image[11881]=136; image[11882]=239; image[11883]=255; image[11884]=255; image[11885]=255; image[11886]=255; image[11887]=255; image[11888]=255; image[11889]=255; image[11890]=255; image[11891]=255; image[11892]=255; image[11893]=255; image[11894]=255; image[11895]=255; image[11896]=243; image[11897]=243; image[11898]=255; image[11899]=63; image[11900]=65; image[11901]=18; image[11902]=3; image[11903]=1; image[11904]=1; image[11905]=1; image[11906]=1; image[11907]=1; image[11908]=1; image[11909]=1; image[11910]=1; image[11911]=1; image[11912]=1; image[11913]=1; image[11914]=1; image[11915]=1; image[11916]=1; image[11917]=1; image[11918]=1; image[11919]=1; image[11920]=1; image[11921]=1; image[11922]=1; image[11923]=1; image[11924]=1; image[11925]=1; image[11926]=1; image[11927]=1; image[11928]=1; image[11929]=1; image[11930]=1; image[11931]=1; image[11932]=1; image[11933]=1; image[11934]=1; image[11935]=1; image[11936]=1; image[11937]=1; image[11938]=1; image[11939]=1; image[11940]=1; image[11941]=1; image[11942]=1; image[11943]=1; image[11944]=1; image[11945]=1; image[11946]=1; image[11947]=1; image[11948]=1; image[11949]=1; image[11950]=1; image[11951]=1; image[11952]=1; image[11953]=1; image[11954]=1; image[11955]=1; image[11956]=1; image[11957]=1; image[11958]=1; image[11959]=1; image[11960]=1; image[11961]=1; image[11962]=1; image[11963]=1; image[11964]=1; image[11965]=1; image[11966]=1; image[11967]=1; image[11968]=1; image[11969]=1; image[11970]=1; image[11971]=1; image[11972]=1; image[11973]=1; image[11974]=1; image[11975]=1; image[11976]=1; image[11977]=1; image[11978]=1; image[11979]=1; image[11980]=1; image[11981]=1; image[11982]=1; image[11983]=1; image[11984]=1; image[11985]=1; image[11986]=1; image[11987]=1; image[11988]=1; image[11989]=1; image[11990]=1; image[11991]=1; image[11992]=1; image[11993]=1; image[11994]=1; image[11995]=2; image[11996]=2; image[11997]=2; image[11998]=2; image[11999]=1; image[12000]=1; image[12001]=1; image[12002]=1; image[12003]=1; image[12004]=1; image[12005]=1; image[12006]=1; image[12007]=1; image[12008]=1; image[12009]=1; image[12010]=4; image[12011]=7; image[12012]=10; image[12013]=8; image[12014]=8; image[12015]=9; image[12016]=12; image[12017]=11; image[12018]=11; image[12019]=13; image[12020]=7; image[12021]=13; image[12022]=19; image[12023]=22; image[12024]=24; image[12025]=24; image[12026]=28; image[12027]=29; image[12028]=31; image[12029]=31; image[12030]=31; image[12031]=28; image[12032]=24; image[12033]=23; image[12034]=22; image[12035]=25; image[12036]=28; image[12037]=16; image[12038]=31; image[12039]=80; image[12040]=42; image[12041]=32; image[12042]=46; image[12043]=56; image[12044]=55; image[12045]=51; image[12046]=53; image[12047]=44; image[12048]=43; image[12049]=61; image[12050]=96; image[12051]=63; image[12052]=22; image[12053]=27; image[12054]=89; image[12055]=231; image[12056]=252; image[12057]=255; image[12058]=255; image[12059]=250; image[12060]=212; image[12061]=196; image[12062]=213; image[12063]=178; image[12064]=116; image[12065]=127; image[12066]=184; image[12067]=232; image[12068]=252; image[12069]=255; image[12070]=255; image[12071]=255; image[12072]=255; image[12073]=255; image[12074]=255; image[12075]=255; image[12076]=255; image[12077]=255; image[12078]=156; image[12079]=102; image[12080]=97; image[12081]=212; image[12082]=255; image[12083]=255; image[12084]=255; image[12085]=255; image[12086]=255; image[12087]=255; image[12088]=255; image[12089]=255; image[12090]=255; image[12091]=255; image[12092]=255; image[12093]=255; image[12094]=255; image[12095]=255; image[12096]=243; image[12097]=255; image[12098]=47; image[12099]=64; image[12100]=19; image[12101]=3; image[12102]=1; image[12103]=1; image[12104]=1; image[12105]=1; image[12106]=1; image[12107]=1; image[12108]=1; image[12109]=1; image[12110]=1; image[12111]=1; image[12112]=1; image[12113]=1; image[12114]=1; image[12115]=1; image[12116]=1; image[12117]=1; image[12118]=1; image[12119]=1; image[12120]=1; image[12121]=1; image[12122]=1; image[12123]=1; image[12124]=1; image[12125]=1; image[12126]=1; image[12127]=1; image[12128]=1; image[12129]=1; image[12130]=1; image[12131]=1; image[12132]=1; image[12133]=1; image[12134]=1; image[12135]=1; image[12136]=1; image[12137]=1; image[12138]=1; image[12139]=1; image[12140]=1; image[12141]=1; image[12142]=1; image[12143]=1; image[12144]=1; image[12145]=1; image[12146]=1; image[12147]=1; image[12148]=1; image[12149]=1; image[12150]=1; image[12151]=1; image[12152]=1; image[12153]=1; image[12154]=1; image[12155]=1; image[12156]=1; image[12157]=1; image[12158]=1; image[12159]=1; image[12160]=1; image[12161]=1; image[12162]=1; image[12163]=1; image[12164]=1; image[12165]=1; image[12166]=1; image[12167]=1; image[12168]=1; image[12169]=1; image[12170]=1; image[12171]=1; image[12172]=1; image[12173]=1; image[12174]=1; image[12175]=1; image[12176]=1; image[12177]=1; image[12178]=1; image[12179]=1; image[12180]=1; image[12181]=1; image[12182]=1; image[12183]=1; image[12184]=1; image[12185]=1; image[12186]=1; image[12187]=1; image[12188]=1; image[12189]=1; image[12190]=1; image[12191]=1; image[12192]=1; image[12193]=1; image[12194]=1; image[12195]=3; image[12196]=2; image[12197]=2; image[12198]=2; image[12199]=1; image[12200]=1; image[12201]=1; image[12202]=1; image[12203]=1; image[12204]=1; image[12205]=1; image[12206]=1; image[12207]=1; image[12208]=1; image[12209]=2; image[12210]=8; image[12211]=12; image[12212]=8; image[12213]=7; image[12214]=9; image[12215]=13; image[12216]=12; image[12217]=9; image[12218]=11; image[12219]=6; image[12220]=10; image[12221]=19; image[12222]=22; image[12223]=24; image[12224]=26; image[12225]=26; image[12226]=25; image[12227]=29; image[12228]=25; image[12229]=22; image[12230]=22; image[12231]=21; image[12232]=19; image[12233]=20; image[12234]=18; image[12235]=15; image[12236]=11; image[12237]=14; image[12238]=52; image[12239]=66; image[12240]=32; image[12241]=38; image[12242]=58; image[12243]=47; image[12244]=50; image[12245]=62; image[12246]=56; image[12247]=47; image[12248]=37; image[12249]=64; image[12250]=89; image[12251]=35; image[12252]=15; image[12253]=12; image[12254]=37; image[12255]=87; image[12256]=121; image[12257]=155; image[12258]=188; image[12259]=246; image[12260]=242; image[12261]=200; image[12262]=223; image[12263]=222; image[12264]=188; image[12265]=211; image[12266]=248; image[12267]=255; image[12268]=250; image[12269]=240; image[12270]=253; image[12271]=253; image[12272]=255; image[12273]=255; image[12274]=255; image[12275]=255; image[12276]=255; image[12277]=255; image[12278]=211; image[12279]=104; image[12280]=131; image[12281]=225; image[12282]=255; image[12283]=255; image[12284]=255; image[12285]=255; image[12286]=255; image[12287]=255; image[12288]=255; image[12289]=255; image[12290]=255; image[12291]=255; image[12292]=255; image[12293]=255; image[12294]=251; image[12295]=253; image[12296]=255; image[12297]=29; image[12298]=64; image[12299]=20; image[12300]=2; image[12301]=1; image[12302]=1; image[12303]=1; image[12304]=1; image[12305]=1; image[12306]=1; image[12307]=1; image[12308]=1; image[12309]=1; image[12310]=1; image[12311]=1; image[12312]=1; image[12313]=1; image[12314]=1; image[12315]=1; image[12316]=1; image[12317]=1; image[12318]=1; image[12319]=1; image[12320]=1; image[12321]=1; image[12322]=1; image[12323]=1; image[12324]=1; image[12325]=1; image[12326]=1; image[12327]=1; image[12328]=1; image[12329]=1; image[12330]=1; image[12331]=1; image[12332]=1; image[12333]=1; image[12334]=1; image[12335]=1; image[12336]=1; image[12337]=1; image[12338]=1; image[12339]=1; image[12340]=1; image[12341]=1; image[12342]=1; image[12343]=1; image[12344]=1; image[12345]=1; image[12346]=1; image[12347]=1; image[12348]=1; image[12349]=1; image[12350]=1; image[12351]=1; image[12352]=1; image[12353]=1; image[12354]=1; image[12355]=1; image[12356]=1; image[12357]=1; image[12358]=1; image[12359]=1; image[12360]=1; image[12361]=1; image[12362]=1; image[12363]=1; image[12364]=1; image[12365]=1; image[12366]=1; image[12367]=1; image[12368]=1; image[12369]=1; image[12370]=1; image[12371]=1; image[12372]=1; image[12373]=1; image[12374]=1; image[12375]=1; image[12376]=1; image[12377]=1; image[12378]=1; image[12379]=1; image[12380]=1; image[12381]=1; image[12382]=1; image[12383]=1; image[12384]=1; image[12385]=1; image[12386]=1; image[12387]=1; image[12388]=1; image[12389]=1; image[12390]=1; image[12391]=1; image[12392]=1; image[12393]=2; image[12394]=3; image[12395]=2; image[12396]=2; image[12397]=2; image[12398]=2; image[12399]=2; image[12400]=1; image[12401]=1; image[12402]=1; image[12403]=1; image[12404]=1; image[12405]=1; image[12406]=1; image[12407]=1; image[12408]=1; image[12409]=7; image[12410]=12; image[12411]=9; image[12412]=7; image[12413]=8; image[12414]=12; image[12415]=14; image[12416]=10; image[12417]=12; image[12418]=7; image[12419]=11; image[12420]=18; image[12421]=21; image[12422]=20; image[12423]=23; image[12424]=24; image[12425]=20; image[12426]=20; image[12427]=21; image[12428]=19; image[12429]=17; image[12430]=16; image[12431]=12; image[12432]=12; image[12433]=10; image[12434]=6; image[12435]=10; image[12436]=11; image[12437]=30; image[12438]=70; image[12439]=54; image[12440]=37; image[12441]=47; image[12442]=48; image[12443]=48; image[12444]=55; image[12445]=56; image[12446]=55; image[12447]=50; image[12448]=52; image[12449]=80; image[12450]=43; image[12451]=14; image[12452]=9; image[12453]=10; image[12454]=21; image[12455]=39; image[12456]=55; image[12457]=74; image[12458]=136; image[12459]=179; image[12460]=178; image[12461]=174; image[12462]=186; image[12463]=168; image[12464]=180; image[12465]=227; image[12466]=247; image[12467]=244; image[12468]=232; image[12469]=248; image[12470]=248; image[12471]=255; image[12472]=255; image[12473]=255; image[12474]=255; image[12475]=255; image[12476]=255; image[12477]=237; image[12478]=139; image[12479]=102; image[12480]=159; image[12481]=233; image[12482]=255; image[12483]=255; image[12484]=255; image[12485]=255; image[12486]=255; image[12487]=255; image[12488]=255; image[12489]=255; image[12490]=255; image[12491]=255; image[12492]=255; image[12493]=238; image[12494]=246; image[12495]=238; image[12496]=35; image[12497]=60; image[12498]=16; image[12499]=2; image[12500]=1; image[12501]=1; image[12502]=1; image[12503]=1; image[12504]=1; image[12505]=1; image[12506]=1; image[12507]=1; image[12508]=1; image[12509]=1; image[12510]=1; image[12511]=1; image[12512]=1; image[12513]=1; image[12514]=1; image[12515]=1; image[12516]=1; image[12517]=1; image[12518]=1; image[12519]=1; image[12520]=1; image[12521]=1; image[12522]=1; image[12523]=1; image[12524]=1; image[12525]=1; image[12526]=1; image[12527]=1; image[12528]=1; image[12529]=1; image[12530]=1; image[12531]=1; image[12532]=1; image[12533]=1; image[12534]=1; image[12535]=1; image[12536]=1; image[12537]=1; image[12538]=1; image[12539]=1; image[12540]=1; image[12541]=1; image[12542]=1; image[12543]=1; image[12544]=1; image[12545]=1; image[12546]=1; image[12547]=1; image[12548]=1; image[12549]=1; image[12550]=1; image[12551]=1; image[12552]=1; image[12553]=1; image[12554]=1; image[12555]=1; image[12556]=1; image[12557]=1; image[12558]=1; image[12559]=1; image[12560]=1; image[12561]=1; image[12562]=1; image[12563]=1; image[12564]=1; image[12565]=1; image[12566]=1; image[12567]=1; image[12568]=1; image[12569]=1; image[12570]=1; image[12571]=1; image[12572]=1; image[12573]=1; image[12574]=1; image[12575]=1; image[12576]=1; image[12577]=1; image[12578]=1; image[12579]=1; image[12580]=1; image[12581]=1; image[12582]=1; image[12583]=1; image[12584]=1; image[12585]=1; image[12586]=1; image[12587]=1; image[12588]=1; image[12589]=1; image[12590]=1; image[12591]=1; image[12592]=3; image[12593]=3; image[12594]=3; image[12595]=3; image[12596]=3; image[12597]=2; image[12598]=2; image[12599]=1; image[12600]=1; image[12601]=1; image[12602]=1; image[12603]=1; image[12604]=1; image[12605]=1; image[12606]=1; image[12607]=1; image[12608]=6; image[12609]=10; image[12610]=11; image[12611]=7; image[12612]=7; image[12613]=11; image[12614]=14; image[12615]=10; image[12616]=11; image[12617]=7; image[12618]=10; image[12619]=17; image[12620]=21; image[12621]=17; image[12622]=18; image[12623]=18; image[12624]=13; image[12625]=13; image[12626]=13; image[12627]=13; image[12628]=10; image[12629]=8; image[12630]=8; image[12631]=9; image[12632]=8; image[12633]=11; image[12634]=20; image[12635]=16; image[12636]=22; image[12637]=64; image[12638]=75; image[12639]=47; image[12640]=40; image[12641]=52; image[12642]=46; image[12643]=43; image[12644]=46; image[12645]=56; image[12646]=64; image[12647]=41; image[12648]=57; image[12649]=47; image[12650]=9; image[12651]=4; image[12652]=4; image[12653]=4; image[12654]=3; image[12655]=6; image[12656]=11; image[12657]=15; image[12658]=41; image[12659]=120; image[12660]=178; image[12661]=167; image[12662]=155; image[12663]=151; image[12664]=213; image[12665]=255; image[12666]=255; image[12667]=255; image[12668]=255; image[12669]=255; image[12670]=255; image[12671]=255; image[12672]=255; image[12673]=255; image[12674]=255; image[12675]=255; image[12676]=255; image[12677]=200; image[12678]=117; image[12679]=104; image[12680]=160; image[12681]=249; image[12682]=255; image[12683]=255; image[12684]=255; image[12685]=255; image[12686]=255; image[12687]=255; image[12688]=255; image[12689]=255; image[12690]=255; image[12691]=255; image[12692]=231; image[12693]=244; image[12694]=192; image[12695]=44; image[12696]=65; image[12697]=18; image[12698]=2; image[12699]=1; image[12700]=1; image[12701]=1; image[12702]=1; image[12703]=1; image[12704]=1; image[12705]=1; image[12706]=1; image[12707]=1; image[12708]=1; image[12709]=1; image[12710]=1; image[12711]=1; image[12712]=1; image[12713]=1; image[12714]=1; image[12715]=1; image[12716]=1; image[12717]=1; image[12718]=1; image[12719]=1; image[12720]=1; image[12721]=1; image[12722]=1; image[12723]=1; image[12724]=1; image[12725]=1; image[12726]=1; image[12727]=1; image[12728]=1; image[12729]=1; image[12730]=1; image[12731]=1; image[12732]=1; image[12733]=1; image[12734]=1; image[12735]=1; image[12736]=1; image[12737]=1; image[12738]=1; image[12739]=1; image[12740]=1; image[12741]=1; image[12742]=1; image[12743]=1; image[12744]=1; image[12745]=1; image[12746]=1; image[12747]=1; image[12748]=1; image[12749]=1; image[12750]=1; image[12751]=1; image[12752]=1; image[12753]=1; image[12754]=1; image[12755]=1; image[12756]=1; image[12757]=1; image[12758]=1; image[12759]=1; image[12760]=1; image[12761]=1; image[12762]=1; image[12763]=1; image[12764]=1; image[12765]=1; image[12766]=1; image[12767]=1; image[12768]=1; image[12769]=1; image[12770]=1; image[12771]=1; image[12772]=1; image[12773]=1; image[12774]=1; image[12775]=1; image[12776]=1; image[12777]=1; image[12778]=1; image[12779]=1; image[12780]=1; image[12781]=1; image[12782]=1; image[12783]=1; image[12784]=1; image[12785]=1; image[12786]=1; image[12787]=1; image[12788]=1; image[12789]=1; image[12790]=1; image[12791]=3; image[12792]=2; image[12793]=3; image[12794]=4; image[12795]=4; image[12796]=2; image[12797]=2; image[12798]=1; image[12799]=1; image[12800]=1; image[12801]=1; image[12802]=1; image[12803]=1; image[12804]=1; image[12805]=1; image[12806]=1; image[12807]=3; image[12808]=6; image[12809]=10; image[12810]=8; image[12811]=6; image[12812]=10; image[12813]=13; image[12814]=12; image[12815]=12; image[12816]=10; image[12817]=8; image[12818]=11; image[12819]=11; image[12820]=14; image[12821]=14; image[12822]=10; image[12823]=9; image[12824]=7; image[12825]=8; image[12826]=12; image[12827]=19; image[12828]=34; image[12829]=41; image[12830]=41; image[12831]=32; image[12832]=18; image[12833]=6; image[12834]=6; image[12835]=12; image[12836]=43; image[12837]=77; image[12838]=73; image[12839]=58; image[12840]=59; image[12841]=65; image[12842]=53; image[12843]=45; image[12844]=50; image[12845]=57; image[12846]=50; image[12847]=59; image[12848]=101; image[12849]=47; image[12850]=2; image[12851]=11; image[12852]=26; image[12853]=40; image[12854]=42; image[12855]=41; image[12856]=58; image[12857]=79; image[12858]=123; image[12859]=140; image[12860]=126; image[12861]=145; image[12862]=133; image[12863]=110; image[12864]=109; image[12865]=101; image[12866]=151; image[12867]=219; image[12868]=252; image[12869]=255; image[12870]=255; image[12871]=255; image[12872]=255; image[12873]=255; image[12874]=255; image[12875]=255; image[12876]=255; image[12877]=240; image[12878]=121; image[12879]=89; image[12880]=169; image[12881]=253; image[12882]=255; image[12883]=255; image[12884]=255; image[12885]=255; image[12886]=255; image[12887]=255; image[12888]=255; image[12889]=255; image[12890]=254; image[12891]=245; image[12892]=255; image[12893]=128; image[12894]=53; image[12895]=53; image[12896]=15; image[12897]=2; image[12898]=2; image[12899]=1; image[12900]=1; image[12901]=1; image[12902]=1; image[12903]=1; image[12904]=1; image[12905]=1; image[12906]=1; image[12907]=1; image[12908]=1; image[12909]=1; image[12910]=1; image[12911]=1; image[12912]=1; image[12913]=1; image[12914]=1; image[12915]=1; image[12916]=1; image[12917]=1; image[12918]=1; image[12919]=1; image[12920]=1; image[12921]=1; image[12922]=1; image[12923]=1; image[12924]=1; image[12925]=1; image[12926]=1; image[12927]=1; image[12928]=1; image[12929]=1; image[12930]=1; image[12931]=1; image[12932]=1; image[12933]=1; image[12934]=1; image[12935]=1; image[12936]=1; image[12937]=1; image[12938]=1; image[12939]=1; image[12940]=1; image[12941]=1; image[12942]=1; image[12943]=1; image[12944]=1; image[12945]=1; image[12946]=1; image[12947]=1; image[12948]=1; image[12949]=1; image[12950]=1; image[12951]=1; image[12952]=1; image[12953]=1; image[12954]=1; image[12955]=1; image[12956]=1; image[12957]=1; image[12958]=1; image[12959]=1; image[12960]=1; image[12961]=1; image[12962]=1; image[12963]=1; image[12964]=1; image[12965]=1; image[12966]=1; image[12967]=1; image[12968]=1; image[12969]=1; image[12970]=1; image[12971]=1; image[12972]=1; image[12973]=1; image[12974]=1; image[12975]=1; image[12976]=1; image[12977]=1; image[12978]=1; image[12979]=1; image[12980]=1; image[12981]=1; image[12982]=1; image[12983]=1; image[12984]=1; image[12985]=1; image[12986]=1; image[12987]=1; image[12988]=1; image[12989]=1; image[12990]=2; image[12991]=3; image[12992]=4; image[12993]=4; image[12994]=4; image[12995]=3; image[12996]=2; image[12997]=1; image[12998]=1; image[12999]=1; image[13000]=1; image[13001]=1; image[13002]=1; image[13003]=1; image[13004]=1; image[13005]=1; image[13006]=2; image[13007]=5; image[13008]=10; image[13009]=8; image[13010]=7; image[13011]=8; image[13012]=12; image[13013]=13; image[13014]=11; image[13015]=10; image[13016]=6; image[13017]=8; image[13018]=10; image[13019]=12; image[13020]=12; image[13021]=8; image[13022]=8; image[13023]=9; image[13024]=19; image[13025]=25; image[13026]=35; image[13027]=43; image[13028]=42; image[13029]=37; image[13030]=27; image[13031]=12; image[13032]=5; image[13033]=8; image[13034]=12; image[13035]=33; image[13036]=81; image[13037]=91; image[13038]=80; image[13039]=57; image[13040]=55; image[13041]=53; image[13042]=47; image[13043]=50; image[13044]=54; image[13045]=60; image[13046]=56; image[13047]=93; image[13048]=90; image[13049]=9; image[13050]=27; image[13051]=66; image[13052]=84; image[13053]=92; image[13054]=101; image[13055]=128; image[13056]=142; image[13057]=184; image[13058]=174; image[13059]=166; image[13060]=155; image[13061]=97; image[13062]=48; image[13063]=27; image[13064]=21; image[13065]=35; image[13066]=96; image[13067]=159; image[13068]=183; image[13069]=216; image[13070]=251; image[13071]=255; image[13072]=255; image[13073]=255; image[13074]=255; image[13075]=255; image[13076]=255; image[13077]=160; image[13078]=76; image[13079]=105; image[13080]=240; image[13081]=255; image[13082]=255; image[13083]=255; image[13084]=255; image[13085]=255; image[13086]=255; image[13087]=255; image[13088]=255; image[13089]=248; image[13090]=227; image[13091]=255; image[13092]=72; image[13093]=61; image[13094]=57; image[13095]=13; image[13096]=2; image[13097]=2; image[13098]=1; image[13099]=1; image[13100]=1; image[13101]=1; image[13102]=1; image[13103]=1; image[13104]=1; image[13105]=1; image[13106]=1; image[13107]=1; image[13108]=1; image[13109]=1; image[13110]=1; image[13111]=1; image[13112]=1; image[13113]=1; image[13114]=1; image[13115]=1; image[13116]=1; image[13117]=1; image[13118]=1; image[13119]=1; image[13120]=1; image[13121]=1; image[13122]=1; image[13123]=1; image[13124]=1; image[13125]=1; image[13126]=1; image[13127]=1; image[13128]=1; image[13129]=1; image[13130]=1; image[13131]=1; image[13132]=1; image[13133]=1; image[13134]=1; image[13135]=1; image[13136]=1; image[13137]=1; image[13138]=1; image[13139]=1; image[13140]=1; image[13141]=1; image[13142]=1; image[13143]=1; image[13144]=1; image[13145]=1; image[13146]=1; image[13147]=1; image[13148]=1; image[13149]=1; image[13150]=1; image[13151]=1; image[13152]=1; image[13153]=1; image[13154]=1; image[13155]=1; image[13156]=1; image[13157]=1; image[13158]=1; image[13159]=1; image[13160]=1; image[13161]=1; image[13162]=1; image[13163]=1; image[13164]=1; image[13165]=1; image[13166]=1; image[13167]=1; image[13168]=1; image[13169]=1; image[13170]=1; image[13171]=1; image[13172]=1; image[13173]=1; image[13174]=1; image[13175]=1; image[13176]=1; image[13177]=1; image[13178]=1; image[13179]=1; image[13180]=1; image[13181]=1; image[13182]=1; image[13183]=1; image[13184]=1; image[13185]=1; image[13186]=1; image[13187]=1; image[13188]=1; image[13189]=2; image[13190]=3; image[13191]=4; image[13192]=4; image[13193]=4; image[13194]=3; image[13195]=2; image[13196]=1; image[13197]=1; image[13198]=1; image[13199]=1; image[13200]=1; image[13201]=1; image[13202]=1; image[13203]=1; image[13204]=1; image[13205]=2; image[13206]=4; image[13207]=9; image[13208]=8; image[13209]=5; image[13210]=6; image[13211]=9; image[13212]=11; image[13213]=11; image[13214]=11; image[13215]=4; image[13216]=9; image[13217]=12; image[13218]=7; image[13219]=6; image[13220]=6; image[13221]=13; image[13222]=23; image[13223]=39; image[13224]=38; image[13225]=37; image[13226]=46; image[13227]=46; image[13228]=26; image[13229]=17; image[13230]=14; image[13231]=18; image[13232]=21; image[13233]=19; image[13234]=21; image[13235]=51; image[13236]=67; image[13237]=76; image[13238]=68; image[13239]=44; image[13240]=39; image[13241]=43; image[13242]=43; image[13243]=52; image[13244]=54; image[13245]=51; image[13246]=44; image[13247]=108; image[13248]=50; image[13249]=17; image[13250]=57; image[13251]=95; image[13252]=96; image[13253]=100; image[13254]=128; image[13255]=148; image[13256]=180; image[13257]=176; image[13258]=158; image[13259]=154; image[13260]=117; image[13261]=94; image[13262]=92; image[13263]=47; image[13264]=27; image[13265]=27; image[13266]=39; image[13267]=81; image[13268]=149; image[13269]=193; image[13270]=231; image[13271]=255; image[13272]=255; image[13273]=255; image[13274]=255; image[13275]=255; image[13276]=228; image[13277]=65; image[13278]=66; image[13279]=154; image[13280]=255; image[13281]=255; image[13282]=255; image[13283]=255; image[13284]=255; image[13285]=255; image[13286]=255; image[13287]=255; image[13288]=246; image[13289]=219; image[13290]=220; image[13291]=47; image[13292]=71; image[13293]=42; image[13294]=9; image[13295]=2; image[13296]=1; image[13297]=1; image[13298]=1; image[13299]=1; image[13300]=2; image[13301]=1; image[13302]=1; image[13303]=1; image[13304]=1; image[13305]=1; image[13306]=1; image[13307]=1; image[13308]=1; image[13309]=1; image[13310]=1; image[13311]=1; image[13312]=1; image[13313]=1; image[13314]=1; image[13315]=1; image[13316]=1; image[13317]=1; image[13318]=1; image[13319]=1; image[13320]=1; image[13321]=1; image[13322]=1; image[13323]=1; image[13324]=1; image[13325]=1; image[13326]=1; image[13327]=1; image[13328]=1; image[13329]=1; image[13330]=1; image[13331]=1; image[13332]=1; image[13333]=1; image[13334]=1; image[13335]=1; image[13336]=1; image[13337]=1; image[13338]=1; image[13339]=1; image[13340]=1; image[13341]=1; image[13342]=1; image[13343]=1; image[13344]=1; image[13345]=1; image[13346]=1; image[13347]=1; image[13348]=1; image[13349]=1; image[13350]=1; image[13351]=1; image[13352]=1; image[13353]=1; image[13354]=1; image[13355]=1; image[13356]=1; image[13357]=1; image[13358]=1; image[13359]=1; image[13360]=1; image[13361]=1; image[13362]=1; image[13363]=1; image[13364]=1; image[13365]=1; image[13366]=1; image[13367]=1; image[13368]=1; image[13369]=1; image[13370]=1; image[13371]=1; image[13372]=1; image[13373]=1; image[13374]=1; image[13375]=1; image[13376]=1; image[13377]=1; image[13378]=1; image[13379]=1; image[13380]=1; image[13381]=1; image[13382]=1; image[13383]=1; image[13384]=1; image[13385]=1; image[13386]=1; image[13387]=2; image[13388]=2; image[13389]=2; image[13390]=3; image[13391]=3; image[13392]=4; image[13393]=3; image[13394]=3; image[13395]=2; image[13396]=1; image[13397]=1; image[13398]=1; image[13399]=1; image[13400]=1; image[13401]=1; image[13402]=1; image[13403]=1; image[13404]=1; image[13405]=2; image[13406]=8; image[13407]=9; image[13408]=6; image[13409]=7; image[13410]=8; image[13411]=10; image[13412]=10; image[13413]=11; image[13414]=4; image[13415]=4; image[13416]=4; image[13417]=8; image[13418]=13; image[13419]=20; image[13420]=23; image[13421]=28; image[13422]=31; image[13423]=34; image[13424]=31; image[13425]=27; image[13426]=22; image[13427]=15; image[13428]=18; image[13429]=22; image[13430]=27; image[13431]=33; image[13432]=26; image[13433]=23; image[13434]=35; image[13435]=48; image[13436]=54; image[13437]=50; image[13438]=37; image[13439]=32; image[13440]=51; image[13441]=59; image[13442]=58; image[13443]=53; image[13444]=53; image[13445]=40; image[13446]=60; image[13447]=79; image[13448]=27; image[13449]=31; image[13450]=84; image[13451]=92; image[13452]=91; image[13453]=112; image[13454]=146; image[13455]=175; image[13456]=158; image[13457]=130; image[13458]=146; image[13459]=131; image[13460]=132; image[13461]=163; image[13462]=140; image[13463]=105; image[13464]=70; image[13465]=57; image[13466]=80; image[13467]=128; image[13468]=163; image[13469]=174; image[13470]=179; image[13471]=237; image[13472]=255; image[13473]=255; image[13474]=255; image[13475]=250; image[13476]=142; image[13477]=53; image[13478]=85; image[13479]=197; image[13480]=255; image[13481]=255; image[13482]=255; image[13483]=255; image[13484]=255; image[13485]=255; image[13486]=255; image[13487]=253; image[13488]=254; image[13489]=151; image[13490]=43; image[13491]=62; image[13492]=24; image[13493]=5; image[13494]=2; image[13495]=1; image[13496]=1; image[13497]=1; image[13498]=1; image[13499]=1; image[13500]=1; image[13501]=1; image[13502]=1; image[13503]=1; image[13504]=1; image[13505]=1; image[13506]=1; image[13507]=1; image[13508]=1; image[13509]=1; image[13510]=1; image[13511]=1; image[13512]=1; image[13513]=1; image[13514]=1; image[13515]=1; image[13516]=1; image[13517]=1; image[13518]=1; image[13519]=1; image[13520]=1; image[13521]=1; image[13522]=1; image[13523]=1; image[13524]=1; image[13525]=1; image[13526]=1; image[13527]=1; image[13528]=1; image[13529]=1; image[13530]=1; image[13531]=1; image[13532]=1; image[13533]=1; image[13534]=1; image[13535]=1; image[13536]=1; image[13537]=1; image[13538]=1; image[13539]=1; image[13540]=1; image[13541]=1; image[13542]=1; image[13543]=1; image[13544]=1; image[13545]=1; image[13546]=1; image[13547]=1; image[13548]=1; image[13549]=1; image[13550]=1; image[13551]=1; image[13552]=1; image[13553]=1; image[13554]=1; image[13555]=1; image[13556]=1; image[13557]=1; image[13558]=1; image[13559]=1; image[13560]=1; image[13561]=1; image[13562]=1; image[13563]=1; image[13564]=1; image[13565]=1; image[13566]=1; image[13567]=1; image[13568]=1; image[13569]=1; image[13570]=1; image[13571]=1; image[13572]=1; image[13573]=1; image[13574]=1; image[13575]=1; image[13576]=1; image[13577]=1; image[13578]=1; image[13579]=1; image[13580]=1; image[13581]=1; image[13582]=1; image[13583]=1; image[13584]=1; image[13585]=1; image[13586]=2; image[13587]=2; image[13588]=2; image[13589]=2; image[13590]=2; image[13591]=4; image[13592]=3; image[13593]=3; image[13594]=2; image[13595]=1; image[13596]=1; image[13597]=1; image[13598]=1; image[13599]=1; image[13600]=1; image[13601]=1; image[13602]=1; image[13603]=1; image[13604]=1; image[13605]=5; image[13606]=7; image[13607]=6; image[13608]=8; image[13609]=7; image[13610]=11; image[13611]=10; image[13612]=12; image[13613]=4; image[13614]=3; image[13615]=5; image[13616]=17; image[13617]=25; image[13618]=27; image[13619]=27; image[13620]=28; image[13621]=27; image[13622]=26; image[13623]=20; image[13624]=13; image[13625]=12; image[13626]=20; image[13627]=21; image[13628]=22; image[13629]=32; image[13630]=36; image[13631]=27; image[13632]=22; image[13633]=29; image[13634]=41; image[13635]=57; image[13636]=51; image[13637]=39; image[13638]=33; image[13639]=47; image[13640]=70; image[13641]=59; image[13642]=52; image[13643]=54; image[13644]=46; image[13645]=36; image[13646]=79; image[13647]=59; image[13648]=23; image[13649]=56; image[13650]=80; image[13651]=84; image[13652]=125; image[13653]=152; image[13654]=177; image[13655]=169; image[13656]=160; image[13657]=186; image[13658]=161; image[13659]=162; image[13660]=168; image[13661]=165; image[13662]=150; image[13663]=123; image[13664]=90; image[13665]=80; image[13666]=97; image[13667]=132; image[13668]=160; image[13669]=131; image[13670]=162; image[13671]=238; image[13672]=255; image[13673]=255; image[13674]=255; image[13675]=190; image[13676]=56; image[13677]=59; image[13678]=140; image[13679]=246; image[13680]=255; image[13681]=255; image[13682]=255; image[13683]=255; image[13684]=255; image[13685]=255; image[13686]=250; image[13687]=231; image[13688]=104; image[13689]=42; image[13690]=40; image[13691]=11; image[13692]=2; image[13693]=1; image[13694]=1; image[13695]=1; image[13696]=1; image[13697]=1; image[13698]=1; image[13699]=1; image[13700]=1; image[13701]=1; image[13702]=1; image[13703]=1; image[13704]=1; image[13705]=1; image[13706]=1; image[13707]=1; image[13708]=1; image[13709]=1; image[13710]=1; image[13711]=1; image[13712]=1; image[13713]=1; image[13714]=1; image[13715]=1; image[13716]=1; image[13717]=1; image[13718]=1; image[13719]=1; image[13720]=1; image[13721]=1; image[13722]=1; image[13723]=1; image[13724]=1; image[13725]=1; image[13726]=1; image[13727]=1; image[13728]=1; image[13729]=1; image[13730]=1; image[13731]=1; image[13732]=1; image[13733]=1; image[13734]=1; image[13735]=1; image[13736]=1; image[13737]=1; image[13738]=1; image[13739]=1; image[13740]=1; image[13741]=1; image[13742]=1; image[13743]=1; image[13744]=1; image[13745]=1; image[13746]=1; image[13747]=1; image[13748]=1; image[13749]=1; image[13750]=1; image[13751]=1; image[13752]=1; image[13753]=1; image[13754]=1; image[13755]=1; image[13756]=1; image[13757]=1; image[13758]=1; image[13759]=1; image[13760]=1; image[13761]=1; image[13762]=1; image[13763]=1; image[13764]=1; image[13765]=1; image[13766]=1; image[13767]=1; image[13768]=1; image[13769]=1; image[13770]=1; image[13771]=1; image[13772]=1; image[13773]=1; image[13774]=1; image[13775]=1; image[13776]=1; image[13777]=1; image[13778]=1; image[13779]=1; image[13780]=1; image[13781]=1; image[13782]=1; image[13783]=1; image[13784]=2; image[13785]=1; image[13786]=1; image[13787]=1; image[13788]=2; image[13789]=2; image[13790]=2; image[13791]=2; image[13792]=3; image[13793]=2; image[13794]=1; image[13795]=1; image[13796]=1; image[13797]=1; image[13798]=1; image[13799]=1; image[13800]=1; image[13801]=1; image[13802]=1; image[13803]=1; image[13804]=2; image[13805]=3; image[13806]=5; image[13807]=9; image[13808]=9; image[13809]=11; image[13810]=11; image[13811]=13; image[13812]=8; image[13813]=4; image[13814]=7; image[13815]=11; image[13816]=14; image[13817]=18; image[13818]=15; image[13819]=11; image[13820]=9; image[13821]=8; image[13822]=10; image[13823]=15; image[13824]=21; image[13825]=24; image[13826]=25; image[13827]=27; image[13828]=30; image[13829]=32; image[13830]=28; image[13831]=19; image[13832]=21; image[13833]=39; image[13834]=63; image[13835]=64; image[13836]=56; image[13837]=52; image[13838]=26; image[13839]=27; image[13840]=55; image[13841]=58; image[13842]=50; image[13843]=51; image[13844]=33; image[13845]=52; image[13846]=103; image[13847]=55; image[13848]=29; image[13849]=82; image[13850]=107; image[13851]=126; image[13852]=155; image[13853]=183; image[13854]=180; image[13855]=153; image[13856]=171; image[13857]=143; image[13858]=128; image[13859]=126; image[13860]=130; image[13861]=135; image[13862]=154; image[13863]=143; image[13864]=122; image[13865]=111; image[13866]=107; image[13867]=138; image[13868]=152; image[13869]=161; image[13870]=191; image[13871]=217; image[13872]=238; image[13873]=251; image[13874]=237; image[13875]=105; image[13876]=59; image[13877]=88; image[13878]=201; image[13879]=255; image[13880]=255; image[13881]=255; image[13882]=255; image[13883]=255; image[13884]=255; image[13885]=195; image[13886]=172; image[13887]=43; image[13888]=43; image[13889]=11; image[13890]=2; image[13891]=1; image[13892]=1; image[13893]=1; image[13894]=1; image[13895]=1; image[13896]=1; image[13897]=2; image[13898]=1; image[13899]=1; image[13900]=1; image[13901]=1; image[13902]=1; image[13903]=1; image[13904]=1; image[13905]=1; image[13906]=1; image[13907]=1; image[13908]=1; image[13909]=1; image[13910]=1; image[13911]=1; image[13912]=1; image[13913]=1; image[13914]=1; image[13915]=1; image[13916]=1; image[13917]=1; image[13918]=1; image[13919]=1; image[13920]=1; image[13921]=1; image[13922]=1; image[13923]=1; image[13924]=1; image[13925]=1; image[13926]=1; image[13927]=1; image[13928]=1; image[13929]=1; image[13930]=1; image[13931]=1; image[13932]=1; image[13933]=1; image[13934]=1; image[13935]=1; image[13936]=1; image[13937]=1; image[13938]=1; image[13939]=1; image[13940]=1; image[13941]=1; image[13942]=1; image[13943]=1; image[13944]=1; image[13945]=1; image[13946]=1; image[13947]=1; image[13948]=1; image[13949]=1; image[13950]=1; image[13951]=1; image[13952]=1; image[13953]=1; image[13954]=1; image[13955]=1; image[13956]=1; image[13957]=1; image[13958]=1; image[13959]=1; image[13960]=1; image[13961]=1; image[13962]=1; image[13963]=1; image[13964]=1; image[13965]=1; image[13966]=1; image[13967]=1; image[13968]=1; image[13969]=1; image[13970]=1; image[13971]=1; image[13972]=1; image[13973]=1; image[13974]=1; image[13975]=1; image[13976]=1; image[13977]=1; image[13978]=1; image[13979]=1; image[13980]=1; image[13981]=1; image[13982]=1; image[13983]=1; image[13984]=1; image[13985]=1; image[13986]=1; image[13987]=2; image[13988]=2; image[13989]=2; image[13990]=3; image[13991]=3; image[13992]=2; image[13993]=1; image[13994]=1; image[13995]=1; image[13996]=1; image[13997]=1; image[13998]=1; image[13999]=1; image[14000]=1; image[14001]=1; image[14002]=1; image[14003]=1; image[14004]=3; image[14005]=6; image[14006]=9; image[14007]=10; image[14008]=12; image[14009]=11; image[14010]=12; image[14011]=11; image[14012]=5; image[14013]=3; image[14014]=4; image[14015]=5; image[14016]=8; image[14017]=9; image[14018]=8; image[14019]=7; image[14020]=10; image[14021]=15; image[14022]=24; image[14023]=29; image[14024]=26; image[14025]=22; image[14026]=23; image[14027]=29; image[14028]=32; image[14029]=32; image[14030]=29; image[14031]=29; image[14032]=42; image[14033]=59; image[14034]=61; image[14035]=54; image[14036]=64; image[14037]=57; image[14038]=22; image[14039]=24; image[14040]=44; image[14041]=47; image[14042]=49; image[14043]=38; image[14044]=40; image[14045]=100; image[14046]=104; image[14047]=65; image[14048]=137; image[14049]=160; image[14050]=103; image[14051]=138; image[14052]=170; image[14053]=139; image[14054]=91; image[14055]=110; image[14056]=114; image[14057]=120; image[14058]=127; image[14059]=143; image[14060]=135; image[14061]=139; image[14062]=141; image[14063]=126; image[14064]=121; image[14065]=111; image[14066]=124; image[14067]=129; image[14068]=144; image[14069]=174; image[14070]=186; image[14071]=196; image[14072]=222; image[14073]=238; image[14074]=143; image[14075]=87; image[14076]=71; image[14077]=146; image[14078]=245; image[14079]=255; image[14080]=255; image[14081]=255; image[14082]=255; image[14083]=255; image[14084]=238; image[14085]=169; image[14086]=30; image[14087]=31; image[14088]=6; image[14089]=2; image[14090]=1; image[14091]=1; image[14092]=1; image[14093]=1; image[14094]=1; image[14095]=1; image[14096]=2; image[14097]=1; image[14098]=1; image[14099]=1; image[14100]=1; image[14101]=1; image[14102]=1; image[14103]=1; image[14104]=1; image[14105]=1; image[14106]=1; image[14107]=1; image[14108]=1; image[14109]=1; image[14110]=1; image[14111]=1; image[14112]=1; image[14113]=1; image[14114]=1; image[14115]=1; image[14116]=1; image[14117]=1; image[14118]=1; image[14119]=1; image[14120]=1; image[14121]=1; image[14122]=1; image[14123]=1; image[14124]=1; image[14125]=1; image[14126]=1; image[14127]=1; image[14128]=1; image[14129]=1; image[14130]=1; image[14131]=1; image[14132]=1; image[14133]=1; image[14134]=1; image[14135]=1; image[14136]=1; image[14137]=1; image[14138]=1; image[14139]=1; image[14140]=1; image[14141]=1; image[14142]=1; image[14143]=1; image[14144]=1; image[14145]=1; image[14146]=1; image[14147]=1; image[14148]=1; image[14149]=1; image[14150]=1; image[14151]=1; image[14152]=1; image[14153]=1; image[14154]=1; image[14155]=1; image[14156]=1; image[14157]=1; image[14158]=1; image[14159]=1; image[14160]=1; image[14161]=1; image[14162]=1; image[14163]=1; image[14164]=1; image[14165]=1; image[14166]=1; image[14167]=1; image[14168]=1; image[14169]=1; image[14170]=1; image[14171]=1; image[14172]=1; image[14173]=1; image[14174]=1; image[14175]=1; image[14176]=1; image[14177]=1; image[14178]=1; image[14179]=1; image[14180]=1; image[14181]=1; image[14182]=1; image[14183]=1; image[14184]=1; image[14185]=1; image[14186]=2; image[14187]=1; image[14188]=1; image[14189]=2; image[14190]=2; image[14191]=2; image[14192]=1; image[14193]=1; image[14194]=1; image[14195]=1; image[14196]=1; image[14197]=1; image[14198]=1; image[14199]=1; image[14200]=1; image[14201]=1; image[14202]=1; image[14203]=1; image[14204]=3; image[14205]=8; image[14206]=9; image[14207]=11; image[14208]=11; image[14209]=8; image[14210]=13; image[14211]=6; image[14212]=4; image[14213]=6; image[14214]=7; image[14215]=11; image[14216]=12; image[14217]=10; image[14218]=11; image[14219]=15; image[14220]=20; image[14221]=25; image[14222]=27; image[14223]=29; image[14224]=20; image[14225]=20; image[14226]=32; image[14227]=34; image[14228]=32; image[14229]=39; image[14230]=48; image[14231]=31; image[14232]=38; image[14233]=66; image[14234]=62; image[14235]=58; image[14236]=75; image[14237]=32; image[14238]=9; image[14239]=19; image[14240]=44; image[14241]=44; image[14242]=42; image[14243]=37; image[14244]=79; image[14245]=97; image[14246]=59; image[14247]=133; image[14248]=192; image[14249]=98; image[14250]=93; image[14251]=111; image[14252]=61; image[14253]=17; image[14254]=51; image[14255]=91; image[14256]=122; image[14257]=139; image[14258]=154; image[14259]=144; image[14260]=155; image[14261]=138; image[14262]=108; image[14263]=126; image[14264]=124; image[14265]=128; image[14266]=115; image[14267]=112; image[14268]=131; image[14269]=136; image[14270]=142; image[14271]=166; image[14272]=183; image[14273]=152; image[14274]=131; image[14275]=80; image[14276]=93; image[14277]=209; image[14278]=254; image[14279]=255; image[14280]=255; image[14281]=255; image[14282]=255; image[14283]=220; image[14284]=140; image[14285]=21; image[14286]=29; image[14287]=7; image[14288]=2; image[14289]=1; image[14290]=1; image[14291]=1; image[14292]=1; image[14293]=1; image[14294]=1; image[14295]=1; image[14296]=1; image[14297]=1; image[14298]=1; image[14299]=1; image[14300]=1; image[14301]=1; image[14302]=1; image[14303]=1; image[14304]=1; image[14305]=1; image[14306]=1; image[14307]=1; image[14308]=1; image[14309]=1; image[14310]=1; image[14311]=1; image[14312]=1; image[14313]=1; image[14314]=1; image[14315]=1; image[14316]=1; image[14317]=1; image[14318]=1; image[14319]=1; image[14320]=1; image[14321]=1; image[14322]=1; image[14323]=1; image[14324]=1; image[14325]=1; image[14326]=1; image[14327]=1; image[14328]=1; image[14329]=1; image[14330]=1; image[14331]=1; image[14332]=1; image[14333]=1; image[14334]=1; image[14335]=1; image[14336]=1; image[14337]=1; image[14338]=1; image[14339]=1; image[14340]=1; image[14341]=1; image[14342]=1; image[14343]=1; image[14344]=1; image[14345]=1; image[14346]=1; image[14347]=1; image[14348]=1; image[14349]=1; image[14350]=1; image[14351]=1; image[14352]=1; image[14353]=1; image[14354]=1; image[14355]=1; image[14356]=1; image[14357]=1; image[14358]=1; image[14359]=1; image[14360]=1; image[14361]=1; image[14362]=1; image[14363]=1; image[14364]=1; image[14365]=1; image[14366]=1; image[14367]=1; image[14368]=1; image[14369]=1; image[14370]=1; image[14371]=1; image[14372]=1; image[14373]=1; image[14374]=1; image[14375]=1; image[14376]=1; image[14377]=1; image[14378]=1; image[14379]=1; image[14380]=1; image[14381]=1; image[14382]=1; image[14383]=1; image[14384]=1; image[14385]=1; image[14386]=1; image[14387]=1; image[14388]=2; image[14389]=3; image[14390]=2; image[14391]=1; image[14392]=1; image[14393]=1; image[14394]=1; image[14395]=1; image[14396]=1; image[14397]=1; image[14398]=1; image[14399]=1; image[14400]=1; image[14401]=1; image[14402]=1; image[14403]=1; image[14404]=6; image[14405]=8; image[14406]=11; image[14407]=11; image[14408]=7; image[14409]=15; image[14410]=12; image[14411]=10; image[14412]=13; image[14413]=14; image[14414]=13; image[14415]=15; image[14416]=17; image[14417]=19; image[14418]=19; image[14419]=19; image[14420]=26; image[14421]=27; image[14422]=31; image[14423]=29; image[14424]=25; image[14425]=30; image[14426]=33; image[14427]=29; image[14428]=30; image[14429]=36; image[14430]=33; image[14431]=23; image[14432]=30; image[14433]=66; image[14434]=58; image[14435]=37; image[14436]=14; image[14437]=5; image[14438]=10; image[14439]=37; image[14440]=44; image[14441]=42; image[14442]=37; image[14443]=52; image[14444]=107; image[14445]=67; image[14446]=56; image[14447]=135; image[14448]=200; image[14449]=136; image[14450]=129; image[14451]=113; image[14452]=22; image[14453]=22; image[14454]=68; image[14455]=102; image[14456]=135; image[14457]=150; image[14458]=147; image[14459]=156; image[14460]=147; image[14461]=120; image[14462]=125; image[14463]=129; image[14464]=157; image[14465]=147; image[14466]=139; image[14467]=150; image[14468]=142; image[14469]=136; image[14470]=153; image[14471]=159; image[14472]=140; image[14473]=142; image[14474]=73; image[14475]=73; image[14476]=134; image[14477]=252; image[14478]=255; image[14479]=246; image[14480]=250; image[14481]=252; image[14482]=179; image[14483]=122; image[14484]=27; image[14485]=27; image[14486]=6; image[14487]=2; image[14488]=1; image[14489]=1; image[14490]=1; image[14491]=1; image[14492]=1; image[14493]=1; image[14494]=1; image[14495]=1; image[14496]=1; image[14497]=1; image[14498]=1; image[14499]=1; image[14500]=1; image[14501]=1; image[14502]=1; image[14503]=1; image[14504]=1; image[14505]=1; image[14506]=1; image[14507]=1; image[14508]=1; image[14509]=1; image[14510]=1; image[14511]=1; image[14512]=1; image[14513]=1; image[14514]=1; image[14515]=1; image[14516]=1; image[14517]=1; image[14518]=1; image[14519]=1; image[14520]=1; image[14521]=1; image[14522]=1; image[14523]=1; image[14524]=1; image[14525]=1; image[14526]=1; image[14527]=1; image[14528]=1; image[14529]=1; image[14530]=1; image[14531]=1; image[14532]=1; image[14533]=1; image[14534]=1; image[14535]=1; image[14536]=1; image[14537]=1; image[14538]=1; image[14539]=1; image[14540]=1; image[14541]=1; image[14542]=1; image[14543]=1; image[14544]=1; image[14545]=1; image[14546]=1; image[14547]=1; image[14548]=1; image[14549]=1; image[14550]=1; image[14551]=1; image[14552]=1; image[14553]=1; image[14554]=1; image[14555]=1; image[14556]=1; image[14557]=1; image[14558]=1; image[14559]=1; image[14560]=1; image[14561]=1; image[14562]=1; image[14563]=1; image[14564]=1; image[14565]=1; image[14566]=1; image[14567]=1; image[14568]=1; image[14569]=1; image[14570]=1; image[14571]=1; image[14572]=1; image[14573]=1; image[14574]=1; image[14575]=1; image[14576]=1; image[14577]=1; image[14578]=1; image[14579]=1; image[14580]=1; image[14581]=1; image[14582]=1; image[14583]=1; image[14584]=1; image[14585]=1; image[14586]=1; image[14587]=2; image[14588]=2; image[14589]=2; image[14590]=1; image[14591]=1; image[14592]=1; image[14593]=1; image[14594]=1; image[14595]=1; image[14596]=1; image[14597]=1; image[14598]=1; image[14599]=1; image[14600]=1; image[14601]=1; image[14602]=1; image[14603]=5; image[14604]=7; image[14605]=10; image[14606]=11; image[14607]=7; image[14608]=14; image[14609]=14; image[14610]=8; image[14611]=11; image[14612]=12; image[14613]=13; image[14614]=16; image[14615]=20; image[14616]=22; image[14617]=21; image[14618]=19; image[14619]=27; image[14620]=27; image[14621]=24; image[14622]=27; image[14623]=26; image[14624]=28; image[14625]=30; image[14626]=32; image[14627]=29; image[14628]=22; image[14629]=29; image[14630]=30; image[14631]=19; image[14632]=39; image[14633]=59; image[14634]=46; image[14635]=24; image[14636]=9; image[14637]=10; image[14638]=35; image[14639]=46; image[14640]=39; image[14641]=41; image[14642]=36; image[14643]=110; image[14644]=104; image[14645]=78; image[14646]=119; image[14647]=209; image[14648]=171; image[14649]=123; image[14650]=102; image[14651]=25; image[14652]=9; image[14653]=37; image[14654]=81; image[14655]=118; image[14656]=138; image[14657]=144; image[14658]=151; image[14659]=153; image[14660]=139; image[14661]=128; image[14662]=128; image[14663]=155; image[14664]=139; image[14665]=139; image[14666]=149; image[14667]=149; image[14668]=137; image[14669]=154; image[14670]=169; image[14671]=146; image[14672]=141; image[14673]=58; image[14674]=51; image[14675]=88; image[14676]=217; image[14677]=254; image[14678]=248; image[14679]=251; image[14680]=243; image[14681]=189; image[14682]=118; image[14683]=22; image[14684]=24; image[14685]=5; image[14686]=1; image[14687]=1; image[14688]=1; image[14689]=1; image[14690]=1; image[14691]=1; image[14692]=1; image[14693]=1; image[14694]=1; image[14695]=1; image[14696]=1; image[14697]=1; image[14698]=1; image[14699]=1; image[14700]=1; image[14701]=1; image[14702]=1; image[14703]=1; image[14704]=1; image[14705]=1; image[14706]=1; image[14707]=1; image[14708]=1; image[14709]=1; image[14710]=1; image[14711]=1; image[14712]=1; image[14713]=1; image[14714]=1; image[14715]=1; image[14716]=1; image[14717]=1; image[14718]=1; image[14719]=1; image[14720]=1; image[14721]=1; image[14722]=1; image[14723]=1; image[14724]=1; image[14725]=1; image[14726]=1; image[14727]=1; image[14728]=1; image[14729]=1; image[14730]=1; image[14731]=1; image[14732]=1; image[14733]=1; image[14734]=1; image[14735]=1; image[14736]=1; image[14737]=1; image[14738]=1; image[14739]=1; image[14740]=1; image[14741]=1; image[14742]=1; image[14743]=1; image[14744]=1; image[14745]=1; image[14746]=1; image[14747]=1; image[14748]=1; image[14749]=1; image[14750]=1; image[14751]=1; image[14752]=1; image[14753]=1; image[14754]=1; image[14755]=1; image[14756]=1; image[14757]=1; image[14758]=1; image[14759]=1; image[14760]=1; image[14761]=1; image[14762]=1; image[14763]=1; image[14764]=1; image[14765]=1; image[14766]=1; image[14767]=1; image[14768]=1; image[14769]=1; image[14770]=1; image[14771]=1; image[14772]=1; image[14773]=1; image[14774]=1; image[14775]=1; image[14776]=1; image[14777]=1; image[14778]=1; image[14779]=1; image[14780]=1; image[14781]=1; image[14782]=1; image[14783]=1; image[14784]=1; image[14785]=1; image[14786]=1; image[14787]=1; image[14788]=3; image[14789]=2; image[14790]=1; image[14791]=1; image[14792]=1; image[14793]=1; image[14794]=1; image[14795]=1; image[14796]=1; image[14797]=1; image[14798]=1; image[14799]=1; image[14800]=1; image[14801]=1; image[14802]=4; image[14803]=7; image[14804]=9; image[14805]=11; image[14806]=8; image[14807]=14; image[14808]=18; image[14809]=6; image[14810]=7; image[14811]=9; image[14812]=15; image[14813]=14; image[14814]=17; image[14815]=21; image[14816]=26; image[14817]=32; image[14818]=28; image[14819]=26; image[14820]=24; image[14821]=26; image[14822]=25; image[14823]=34; image[14824]=33; image[14825]=38; image[14826]=42; image[14827]=31; image[14828]=27; image[14829]=44; image[14830]=48; image[14831]=22; image[14832]=12; image[14833]=14; image[14834]=15; image[14835]=14; image[14836]=11; image[14837]=27; image[14838]=44; image[14839]=40; image[14840]=40; image[14841]=26; image[14842]=109; image[14843]=142; image[14844]=106; image[14845]=119; image[14846]=162; image[14847]=164; image[14848]=125; image[14849]=95; image[14850]=30; image[14851]=5; image[14852]=5; image[14853]=24; image[14854]=66; image[14855]=123; image[14856]=169; image[14857]=165; image[14858]=165; image[14859]=166; image[14860]=156; image[14861]=151; image[14862]=142; image[14863]=130; image[14864]=138; image[14865]=134; image[14866]=130; image[14867]=121; image[14868]=121; image[14869]=135; image[14870]=136; image[14871]=122; image[14872]=74; image[14873]=42; image[14874]=61; image[14875]=150; image[14876]=230; image[14877]=255; image[14878]=255; image[14879]=217; image[14880]=195; image[14881]=127; image[14882]=28; image[14883]=23; image[14884]=5; image[14885]=2; image[14886]=1; image[14887]=1; image[14888]=1; image[14889]=1; image[14890]=1; image[14891]=1; image[14892]=1; image[14893]=1; image[14894]=1; image[14895]=1; image[14896]=1; image[14897]=1; image[14898]=1; image[14899]=1; image[14900]=1; image[14901]=1; image[14902]=1; image[14903]=1; image[14904]=1; image[14905]=1; image[14906]=1; image[14907]=1; image[14908]=1; image[14909]=1; image[14910]=1; image[14911]=1; image[14912]=1; image[14913]=1; image[14914]=1; image[14915]=1; image[14916]=1; image[14917]=1; image[14918]=1; image[14919]=1; image[14920]=1; image[14921]=1; image[14922]=1; image[14923]=1; image[14924]=1; image[14925]=1; image[14926]=1; image[14927]=1; image[14928]=1; image[14929]=1; image[14930]=1; image[14931]=1; image[14932]=1; image[14933]=1; image[14934]=1; image[14935]=1; image[14936]=1; image[14937]=1; image[14938]=1; image[14939]=1; image[14940]=1; image[14941]=1; image[14942]=1; image[14943]=1; image[14944]=1; image[14945]=1; image[14946]=1; image[14947]=1; image[14948]=1; image[14949]=1; image[14950]=1; image[14951]=1; image[14952]=1; image[14953]=1; image[14954]=1; image[14955]=1; image[14956]=1; image[14957]=1; image[14958]=1; image[14959]=1; image[14960]=1; image[14961]=1; image[14962]=1; image[14963]=1; image[14964]=1; image[14965]=1; image[14966]=1; image[14967]=1; image[14968]=1; image[14969]=1; image[14970]=1; image[14971]=1; image[14972]=1; image[14973]=1; image[14974]=1; image[14975]=1; image[14976]=1; image[14977]=1; image[14978]=1; image[14979]=1; image[14980]=1; image[14981]=1; image[14982]=1; image[14983]=1; image[14984]=1; image[14985]=1; image[14986]=2; image[14987]=3; image[14988]=2; image[14989]=1; image[14990]=1; image[14991]=1; image[14992]=1; image[14993]=1; image[14994]=1; image[14995]=1; image[14996]=1; image[14997]=1; image[14998]=1; image[14999]=1; image[15000]=1; image[15001]=3; image[15002]=5; image[15003]=9; image[15004]=10; image[15005]=9; image[15006]=11; image[15007]=17; image[15008]=15; image[15009]=8; image[15010]=6; image[15011]=9; image[15012]=10; image[15013]=16; image[15014]=19; image[15015]=24; image[15016]=29; image[15017]=27; image[15018]=27; image[15019]=29; image[15020]=30; image[15021]=24; image[15022]=33; image[15023]=30; image[15024]=27; image[15025]=31; image[15026]=30; image[15027]=31; image[15028]=60; image[15029]=62; image[15030]=38; image[15031]=33; image[15032]=27; image[15033]=16; image[15034]=18; image[15035]=9; image[15036]=21; image[15037]=39; image[15038]=38; image[15039]=40; image[15040]=30; image[15041]=74; image[15042]=152; image[15043]=102; image[15044]=103; image[15045]=120; image[15046]=138; image[15047]=125; image[15048]=131; image[15049]=52; image[15050]=13; image[15051]=9; image[15052]=11; image[15053]=35; image[15054]=68; image[15055]=96; image[15056]=112; image[15057]=124; image[15058]=128; image[15059]=133; image[15060]=133; image[15061]=134; image[15062]=124; image[15063]=126; image[15064]=128; image[15065]=115; image[15066]=116; image[15067]=123; image[15068]=126; image[15069]=134; image[15070]=118; image[15071]=94; image[15072]=40; image[15073]=52; image[15074]=130; image[15075]=212; image[15076]=255; image[15077]=255; image[15078]=185; image[15079]=129; image[15080]=104; image[15081]=33; image[15082]=27; image[15083]=5; image[15084]=1; image[15085]=1; image[15086]=1; image[15087]=1; image[15088]=1; image[15089]=1; image[15090]=1; image[15091]=1; image[15092]=1; image[15093]=1; image[15094]=1; image[15095]=1; image[15096]=1; image[15097]=1; image[15098]=1; image[15099]=1; image[15100]=1; image[15101]=1; image[15102]=1; image[15103]=1; image[15104]=1; image[15105]=1; image[15106]=1; image[15107]=1; image[15108]=1; image[15109]=1; image[15110]=1; image[15111]=1; image[15112]=1; image[15113]=1; image[15114]=1; image[15115]=1; image[15116]=1; image[15117]=1; image[15118]=1; image[15119]=1; image[15120]=1; image[15121]=1; image[15122]=1; image[15123]=1; image[15124]=1; image[15125]=1; image[15126]=1; image[15127]=1; image[15128]=1; image[15129]=1; image[15130]=1; image[15131]=1; image[15132]=1; image[15133]=1; image[15134]=1; image[15135]=1; image[15136]=1; image[15137]=1; image[15138]=1; image[15139]=1; image[15140]=1; image[15141]=1; image[15142]=1; image[15143]=1; image[15144]=1; image[15145]=1; image[15146]=1; image[15147]=1; image[15148]=1; image[15149]=1; image[15150]=1; image[15151]=1; image[15152]=1; image[15153]=1; image[15154]=1; image[15155]=1; image[15156]=1; image[15157]=1; image[15158]=1; image[15159]=1; image[15160]=1; image[15161]=1; image[15162]=1; image[15163]=1; image[15164]=1; image[15165]=1; image[15166]=1; image[15167]=1; image[15168]=1; image[15169]=1; image[15170]=1; image[15171]=1; image[15172]=1; image[15173]=1; image[15174]=1; image[15175]=1; image[15176]=1; image[15177]=1; image[15178]=1; image[15179]=1; image[15180]=1; image[15181]=1; image[15182]=1; image[15183]=1; image[15184]=1; image[15185]=2; image[15186]=3; image[15187]=1; image[15188]=1; image[15189]=1; image[15190]=1; image[15191]=1; image[15192]=1; image[15193]=1; image[15194]=1; image[15195]=1; image[15196]=1; image[15197]=1; image[15198]=1; image[15199]=1; image[15200]=2; image[15201]=5; image[15202]=10; image[15203]=9; image[15204]=9; image[15205]=8; image[15206]=15; image[15207]=23; image[15208]=8; image[15209]=4; image[15210]=11; image[15211]=11; image[15212]=16; image[15213]=21; image[15214]=22; image[15215]=21; image[15216]=26; image[15217]=30; image[15218]=28; image[15219]=30; image[15220]=26; image[15221]=31; image[15222]=27; image[15223]=23; image[15224]=24; image[15225]=24; image[15226]=29; image[15227]=63; image[15228]=42; image[15229]=24; image[15230]=32; image[15231]=30; image[15232]=20; image[15233]=22; image[15234]=7; image[15235]=16; image[15236]=36; image[15237]=37; image[15238]=37; image[15239]=34; image[15240]=53; image[15241]=142; image[15242]=110; image[15243]=108; image[15244]=94; image[15245]=128; image[15246]=162; image[15247]=208; image[15248]=97; image[15249]=21; image[15250]=17; image[15251]=17; image[15252]=29; image[15253]=53; image[15254]=76; image[15255]=86; image[15256]=101; image[15257]=114; image[15258]=122; image[15259]=124; image[15260]=129; image[15261]=123; image[15262]=122; image[15263]=131; image[15264]=125; image[15265]=129; image[15266]=141; image[15267]=138; image[15268]=148; image[15269]=134; image[15270]=114; image[15271]=45; image[15272]=54; image[15273]=120; image[15274]=185; image[15275]=255; image[15276]=255; image[15277]=189; image[15278]=131; image[15279]=116; image[15280]=27; image[15281]=25; image[15282]=4; image[15283]=1; image[15284]=1; image[15285]=1; image[15286]=1; image[15287]=1; image[15288]=1; image[15289]=1; image[15290]=1; image[15291]=1; image[15292]=1; image[15293]=1; image[15294]=1; image[15295]=1; image[15296]=1; image[15297]=1; image[15298]=1; image[15299]=1; image[15300]=1; image[15301]=1; image[15302]=1; image[15303]=1; image[15304]=1; image[15305]=1; image[15306]=1; image[15307]=1; image[15308]=1; image[15309]=1; image[15310]=1; image[15311]=1; image[15312]=1; image[15313]=1; image[15314]=1; image[15315]=1; image[15316]=1; image[15317]=1; image[15318]=1; image[15319]=1; image[15320]=1; image[15321]=1; image[15322]=1; image[15323]=1; image[15324]=1; image[15325]=1; image[15326]=1; image[15327]=1; image[15328]=1; image[15329]=1; image[15330]=1; image[15331]=1; image[15332]=1; image[15333]=1; image[15334]=1; image[15335]=1; image[15336]=1; image[15337]=1; image[15338]=1; image[15339]=1; image[15340]=1; image[15341]=1; image[15342]=1; image[15343]=1; image[15344]=1; image[15345]=1; image[15346]=1; image[15347]=1; image[15348]=1; image[15349]=1; image[15350]=1; image[15351]=1; image[15352]=1; image[15353]=1; image[15354]=1; image[15355]=1; image[15356]=1; image[15357]=1; image[15358]=1; image[15359]=1; image[15360]=1; image[15361]=1; image[15362]=1; image[15363]=1; image[15364]=1; image[15365]=1; image[15366]=1; image[15367]=1; image[15368]=1; image[15369]=1; image[15370]=1; image[15371]=1; image[15372]=1; image[15373]=1; image[15374]=1; image[15375]=1; image[15376]=1; image[15377]=1; image[15378]=1; image[15379]=1; image[15380]=1; image[15381]=1; image[15382]=1; image[15383]=1; image[15384]=2; image[15385]=3; image[15386]=2; image[15387]=1; image[15388]=1; image[15389]=1; image[15390]=1; image[15391]=1; image[15392]=1; image[15393]=1; image[15394]=1; image[15395]=1; image[15396]=1; image[15397]=1; image[15398]=1; image[15399]=2; image[15400]=4; image[15401]=8; image[15402]=11; image[15403]=12; image[15404]=8; image[15405]=13; image[15406]=26; image[15407]=13; image[15408]=5; image[15409]=7; image[15410]=9; image[15411]=16; image[15412]=24; image[15413]=22; image[15414]=21; image[15415]=24; image[15416]=32; image[15417]=32; image[15418]=31; image[15419]=28; image[15420]=25; image[15421]=22; image[15422]=16; image[15423]=16; image[15424]=20; image[15425]=15; image[15426]=18; image[15427]=16; image[15428]=19; image[15429]=29; image[15430]=31; image[15431]=39; image[15432]=43; image[15433]=11; image[15434]=12; image[15435]=37; image[15436]=41; image[15437]=37; image[15438]=34; image[15439]=35; image[15440]=114; image[15441]=125; image[15442]=114; image[15443]=99; image[15444]=144; image[15445]=219; image[15446]=218; image[15447]=95; image[15448]=29; image[15449]=26; image[15450]=30; image[15451]=79; image[15452]=135; image[15453]=106; image[15454]=51; image[15455]=51; image[15456]=85; image[15457]=108; image[15458]=126; image[15459]=133; image[15460]=152; image[15461]=147; image[15462]=136; image[15463]=113; image[15464]=122; image[15465]=130; image[15466]=133; image[15467]=138; image[15468]=152; image[15469]=167; image[15470]=67; image[15471]=52; image[15472]=95; image[15473]=161; image[15474]=255; image[15475]=255; image[15476]=187; image[15477]=152; image[15478]=148; image[15479]=24; image[15480]=21; image[15481]=3; image[15482]=1; image[15483]=1; image[15484]=1; image[15485]=1; image[15486]=1; image[15487]=1; image[15488]=1; image[15489]=1; image[15490]=1; image[15491]=1; image[15492]=1; image[15493]=1; image[15494]=1; image[15495]=1; image[15496]=1; image[15497]=1; image[15498]=1; image[15499]=1; image[15500]=1; image[15501]=1; image[15502]=1; image[15503]=1; image[15504]=1; image[15505]=1; image[15506]=1; image[15507]=1; image[15508]=1; image[15509]=1; image[15510]=1; image[15511]=1; image[15512]=1; image[15513]=1; image[15514]=1; image[15515]=1; image[15516]=1; image[15517]=1; image[15518]=1; image[15519]=1; image[15520]=1; image[15521]=1; image[15522]=1; image[15523]=1; image[15524]=1; image[15525]=1; image[15526]=1; image[15527]=1; image[15528]=1; image[15529]=1; image[15530]=1; image[15531]=1; image[15532]=1; image[15533]=1; image[15534]=1; image[15535]=1; image[15536]=1; image[15537]=1; image[15538]=1; image[15539]=1; image[15540]=1; image[15541]=1; image[15542]=1; image[15543]=1; image[15544]=1; image[15545]=1; image[15546]=1; image[15547]=1; image[15548]=1; image[15549]=1; image[15550]=1; image[15551]=1; image[15552]=1; image[15553]=1; image[15554]=1; image[15555]=1; image[15556]=1; image[15557]=1; image[15558]=1; image[15559]=1; image[15560]=1; image[15561]=1; image[15562]=1; image[15563]=1; image[15564]=1; image[15565]=1; image[15566]=1; image[15567]=1; image[15568]=1; image[15569]=1; image[15570]=1; image[15571]=1; image[15572]=1; image[15573]=1; image[15574]=1; image[15575]=1; image[15576]=1; image[15577]=1; image[15578]=1; image[15579]=1; image[15580]=1; image[15581]=1; image[15582]=1; image[15583]=1; image[15584]=3; image[15585]=3; image[15586]=2; image[15587]=1; image[15588]=1; image[15589]=1; image[15590]=1; image[15591]=1; image[15592]=1; image[15593]=1; image[15594]=1; image[15595]=1; image[15596]=1; image[15597]=1; image[15598]=1; image[15599]=3; image[15600]=8; image[15601]=10; image[15602]=10; image[15603]=8; image[15604]=11; image[15605]=24; image[15606]=17; image[15607]=7; image[15608]=5; image[15609]=11; image[15610]=20; image[15611]=22; image[15612]=23; image[15613]=22; image[15614]=23; image[15615]=26; image[15616]=25; image[15617]=23; image[15618]=21; image[15619]=19; image[15620]=17; image[15621]=15; image[15622]=15; image[15623]=16; image[15624]=13; image[15625]=15; image[15626]=17; image[15627]=24; image[15628]=36; image[15629]=36; image[15630]=40; image[15631]=42; image[15632]=13; image[15633]=12; image[15634]=39; image[15635]=42; image[15636]=34; image[15637]=34; image[15638]=31; image[15639]=102; image[15640]=136; image[15641]=124; image[15642]=105; image[15643]=121; image[15644]=156; image[15645]=148; image[15646]=90; image[15647]=35; image[15648]=26; image[15649]=32; image[15650]=92; image[15651]=215; image[15652]=189; image[15653]=133; image[15654]=115; image[15655]=125; image[15656]=102; image[15657]=104; image[15658]=142; image[15659]=147; image[15660]=135; image[15661]=137; image[15662]=119; image[15663]=126; image[15664]=127; image[15665]=138; image[15666]=154; image[15667]=188; image[15668]=200; image[15669]=86; image[15670]=50; image[15671]=86; image[15672]=157; image[15673]=255; image[15674]=255; image[15675]=184; image[15676]=158; image[15677]=131; image[15678]=25; image[15679]=20; image[15680]=2; image[15681]=1; image[15682]=1; image[15683]=1; image[15684]=1; image[15685]=1; image[15686]=1; image[15687]=1; image[15688]=1; image[15689]=1; image[15690]=1; image[15691]=1; image[15692]=1; image[15693]=1; image[15694]=1; image[15695]=1; image[15696]=1; image[15697]=1; image[15698]=1; image[15699]=1; image[15700]=1; image[15701]=1; image[15702]=1; image[15703]=1; image[15704]=1; image[15705]=1; image[15706]=1; image[15707]=1; image[15708]=1; image[15709]=1; image[15710]=1; image[15711]=1; image[15712]=1; image[15713]=1; image[15714]=1; image[15715]=1; image[15716]=1; image[15717]=1; image[15718]=1; image[15719]=1; image[15720]=1; image[15721]=1; image[15722]=1; image[15723]=1; image[15724]=1; image[15725]=1; image[15726]=1; image[15727]=1; image[15728]=1; image[15729]=1; image[15730]=1; image[15731]=1; image[15732]=1; image[15733]=1; image[15734]=1; image[15735]=1; image[15736]=1; image[15737]=1; image[15738]=1; image[15739]=1; image[15740]=1; image[15741]=1; image[15742]=1; image[15743]=1; image[15744]=1; image[15745]=1; image[15746]=1; image[15747]=1; image[15748]=1; image[15749]=1; image[15750]=1; image[15751]=1; image[15752]=1; image[15753]=1; image[15754]=1; image[15755]=1; image[15756]=1; image[15757]=1; image[15758]=1; image[15759]=1; image[15760]=1; image[15761]=1; image[15762]=1; image[15763]=1; image[15764]=1; image[15765]=1; image[15766]=1; image[15767]=1; image[15768]=1; image[15769]=1; image[15770]=1; image[15771]=1; image[15772]=1; image[15773]=1; image[15774]=1; image[15775]=1; image[15776]=1; image[15777]=1; image[15778]=1; image[15779]=1; image[15780]=1; image[15781]=1; image[15782]=1; image[15783]=2; image[15784]=3; image[15785]=3; image[15786]=1; image[15787]=1; image[15788]=1; image[15789]=1; image[15790]=1; image[15791]=1; image[15792]=1; image[15793]=1; image[15794]=1; image[15795]=1; image[15796]=1; image[15797]=1; image[15798]=2; image[15799]=7; image[15800]=8; image[15801]=9; image[15802]=10; image[15803]=9; image[15804]=21; image[15805]=20; image[15806]=9; image[15807]=5; image[15808]=13; image[15809]=20; image[15810]=22; image[15811]=23; image[15812]=20; image[15813]=18; image[15814]=16; image[15815]=20; image[15816]=18; image[15817]=18; image[15818]=13; image[15819]=12; image[15820]=12; image[15821]=10; image[15822]=14; image[15823]=17; image[15824]=20; image[15825]=23; image[15826]=27; image[15827]=32; image[15828]=36; image[15829]=42; image[15830]=49; image[15831]=16; image[15832]=12; image[15833]=45; image[15834]=47; image[15835]=36; image[15836]=38; image[15837]=30; image[15838]=84; image[15839]=140; image[15840]=136; image[15841]=110; image[15842]=96; image[15843]=109; image[15844]=90; image[15845]=76; image[15846]=32; image[15847]=13; image[15848]=18; image[15849]=60; image[15850]=234; image[15851]=255; image[15852]=255; image[15853]=250; image[15854]=242; image[15855]=166; image[15856]=143; image[15857]=161; image[15858]=131; image[15859]=113; image[15860]=122; image[15861]=120; image[15862]=114; image[15863]=140; image[15864]=160; image[15865]=164; image[15866]=195; image[15867]=199; image[15868]=103; image[15869]=46; image[15870]=73; image[15871]=134; image[15872]=255; image[15873]=255; image[15874]=158; image[15875]=191; image[15876]=128; image[15877]=24; image[15878]=18; image[15879]=2; image[15880]=1; image[15881]=1; image[15882]=1; image[15883]=1; image[15884]=1; image[15885]=1; image[15886]=1; image[15887]=1; image[15888]=1; image[15889]=1; image[15890]=1; image[15891]=1; image[15892]=1; image[15893]=1; image[15894]=1; image[15895]=1; image[15896]=1; image[15897]=1; image[15898]=1; image[15899]=1; image[15900]=1; image[15901]=1; image[15902]=1; image[15903]=1; image[15904]=1; image[15905]=1; image[15906]=1; image[15907]=1; image[15908]=1; image[15909]=1; image[15910]=1; image[15911]=1; image[15912]=1; image[15913]=1; image[15914]=1; image[15915]=1; image[15916]=1; image[15917]=1; image[15918]=1; image[15919]=1; image[15920]=1; image[15921]=1; image[15922]=1; image[15923]=1; image[15924]=0; image[15925]=1; image[15926]=1; image[15927]=1; image[15928]=1; image[15929]=1; image[15930]=1; image[15931]=1; image[15932]=1; image[15933]=1; image[15934]=1; image[15935]=1; image[15936]=1; image[15937]=1; image[15938]=1; image[15939]=1; image[15940]=1; image[15941]=1; image[15942]=1; image[15943]=1; image[15944]=1; image[15945]=1; image[15946]=1; image[15947]=1; image[15948]=1; image[15949]=1; image[15950]=1; image[15951]=1; image[15952]=1; image[15953]=1; image[15954]=1; image[15955]=1; image[15956]=1; image[15957]=1; image[15958]=1; image[15959]=1; image[15960]=1; image[15961]=1; image[15962]=1; image[15963]=1; image[15964]=1; image[15965]=1; image[15966]=1; image[15967]=1; image[15968]=1; image[15969]=1; image[15970]=1; image[15971]=1; image[15972]=1; image[15973]=1; image[15974]=1; image[15975]=1; image[15976]=1; image[15977]=1; image[15978]=1; image[15979]=1; image[15980]=1; image[15981]=1; image[15982]=2; image[15983]=3; image[15984]=3; image[15985]=2; image[15986]=1; image[15987]=1; image[15988]=1; image[15989]=1; image[15990]=1; image[15991]=1; image[15992]=1; image[15993]=1; image[15994]=1; image[15995]=1; image[15996]=1; image[15997]=2; image[15998]=7; image[15999]=9; image[16000]=11; image[16001]=10; image[16002]=8; image[16003]=15; image[16004]=16; image[16005]=9; image[16006]=5; image[16007]=11; image[16008]=17; image[16009]=18; image[16010]=18; image[16011]=18; image[16012]=14; image[16013]=12; image[16014]=9; image[16015]=9; image[16016]=8; image[16017]=11; image[16018]=12; image[16019]=10; image[16020]=14; image[16021]=17; image[16022]=20; image[16023]=32; image[16024]=41; image[16025]=39; image[16026]=38; image[16027]=38; image[16028]=39; image[16029]=43; image[16030]=14; image[16031]=11; image[16032]=44; image[16033]=51; image[16034]=45; image[16035]=45; image[16036]=35; image[16037]=64; image[16038]=138; image[16039]=138; image[16040]=132; image[16041]=105; image[16042]=136; image[16043]=128; image[16044]=49; image[16045]=14; image[16046]=8; image[16047]=7; image[16048]=11; image[16049]=70; image[16050]=148; image[16051]=222; image[16052]=253; image[16053]=255; image[16054]=244; image[16055]=238; image[16056]=243; image[16057]=180; image[16058]=115; image[16059]=165; image[16060]=205; image[16061]=183; image[16062]=196; image[16063]=197; image[16064]=198; image[16065]=209; image[16066]=203; image[16067]=133; image[16068]=43; image[16069]=54; image[16070]=113; image[16071]=252; image[16072]=255; image[16073]=128; image[16074]=160; image[16075]=121; image[16076]=30; image[16077]=16; image[16078]=2; image[16079]=1; image[16080]=1; image[16081]=1; image[16082]=1; image[16083]=1; image[16084]=1; image[16085]=1; image[16086]=1; image[16087]=1; image[16088]=1; image[16089]=1; image[16090]=1; image[16091]=1; image[16092]=1; image[16093]=1; image[16094]=1; image[16095]=1; image[16096]=1; image[16097]=1; image[16098]=1; image[16099]=1; image[16100]=1; image[16101]=1; image[16102]=1; image[16103]=1; image[16104]=1; image[16105]=1; image[16106]=1; image[16107]=1; image[16108]=1; image[16109]=1; image[16110]=1; image[16111]=1; image[16112]=1; image[16113]=1; image[16114]=1; image[16115]=1; image[16116]=1; image[16117]=1; image[16118]=1; image[16119]=1; image[16120]=1; image[16121]=1; image[16122]=1; image[16123]=1; image[16124]=1; image[16125]=1; image[16126]=1; image[16127]=1; image[16128]=1; image[16129]=1; image[16130]=1; image[16131]=1; image[16132]=1; image[16133]=1; image[16134]=1; image[16135]=1; image[16136]=1; image[16137]=1; image[16138]=1; image[16139]=1; image[16140]=1; image[16141]=1; image[16142]=1; image[16143]=1; image[16144]=1; image[16145]=1; image[16146]=1; image[16147]=1; image[16148]=1; image[16149]=1; image[16150]=1; image[16151]=1; image[16152]=1; image[16153]=1; image[16154]=1; image[16155]=1; image[16156]=1; image[16157]=1; image[16158]=1; image[16159]=1; image[16160]=1; image[16161]=1; image[16162]=1; image[16163]=1; image[16164]=1; image[16165]=1; image[16166]=1; image[16167]=1; image[16168]=1; image[16169]=1; image[16170]=1; image[16171]=1; image[16172]=1; image[16173]=1; image[16174]=2; image[16175]=1; image[16176]=1; image[16177]=1; image[16178]=1; image[16179]=1; image[16180]=1; image[16181]=2; image[16182]=3; image[16183]=3; image[16184]=2; image[16185]=1; image[16186]=1; image[16187]=1; image[16188]=1; image[16189]=1; image[16190]=1; image[16191]=1; image[16192]=1; image[16193]=1; image[16194]=1; image[16195]=1; image[16196]=1; image[16197]=6; image[16198]=9; image[16199]=10; image[16200]=10; image[16201]=8; image[16202]=14; image[16203]=16; image[16204]=9; image[16205]=6; image[16206]=12; image[16207]=17; image[16208]=16; image[16209]=15; image[16210]=13; image[16211]=9; image[16212]=9; image[16213]=7; image[16214]=8; image[16215]=11; image[16216]=13; image[16217]=13; image[16218]=10; image[16219]=15; image[16220]=20; image[16221]=26; image[16222]=34; image[16223]=42; image[16224]=40; image[16225]=38; image[16226]=37; image[16227]=43; image[16228]=44; image[16229]=14; image[16230]=10; image[16231]=43; image[16232]=54; image[16233]=52; image[16234]=44; image[16235]=36; image[16236]=52; image[16237]=130; image[16238]=138; image[16239]=141; image[16240]=116; image[16241]=134; image[16242]=146; image[16243]=63; image[16244]=11; image[16245]=12; image[16246]=13; image[16247]=11; image[16248]=43; image[16249]=106; image[16250]=161; image[16251]=220; image[16252]=250; image[16253]=255; image[16254]=255; image[16255]=255; image[16256]=237; image[16257]=148; image[16258]=180; image[16259]=224; image[16260]=248; image[16261]=250; image[16262]=239; image[16263]=212; image[16264]=221; image[16265]=216; image[16266]=139; image[16267]=43; image[16268]=48; image[16269]=112; image[16270]=255; image[16271]=255; image[16272]=121; image[16273]=111; image[16274]=84; image[16275]=26; image[16276]=14; image[16277]=2; image[16278]=1; image[16279]=1; image[16280]=1; image[16281]=1; image[16282]=1; image[16283]=1; image[16284]=1; image[16285]=1; image[16286]=1; image[16287]=1; image[16288]=1; image[16289]=1; image[16290]=1; image[16291]=1; image[16292]=1; image[16293]=1; image[16294]=1; image[16295]=1; image[16296]=1; image[16297]=1; image[16298]=1; image[16299]=1; image[16300]=1; image[16301]=1; image[16302]=1; image[16303]=1; image[16304]=1; image[16305]=1; image[16306]=1; image[16307]=1; image[16308]=1; image[16309]=1; image[16310]=1; image[16311]=1; image[16312]=1; image[16313]=1; image[16314]=1; image[16315]=1; image[16316]=1; image[16317]=1; image[16318]=1; image[16319]=1; image[16320]=1; image[16321]=1; image[16322]=1; image[16323]=1; image[16324]=1; image[16325]=1; image[16326]=1; image[16327]=1; image[16328]=1; image[16329]=1; image[16330]=1; image[16331]=1; image[16332]=1; image[16333]=1; image[16334]=1; image[16335]=1; image[16336]=1; image[16337]=1; image[16338]=1; image[16339]=1; image[16340]=1; image[16341]=1; image[16342]=1; image[16343]=1; image[16344]=1; image[16345]=1; image[16346]=1; image[16347]=1; image[16348]=1; image[16349]=1; image[16350]=1; image[16351]=1; image[16352]=1; image[16353]=1; image[16354]=1; image[16355]=1; image[16356]=1; image[16357]=1; image[16358]=1; image[16359]=1; image[16360]=1; image[16361]=1; image[16362]=1; image[16363]=1; image[16364]=1; image[16365]=1; image[16366]=1; image[16367]=1; image[16368]=1; image[16369]=1; image[16370]=1; image[16371]=1; image[16372]=1; image[16373]=1; image[16374]=1; image[16375]=1; image[16376]=1; image[16377]=1; image[16378]=1; image[16379]=1; image[16380]=2; image[16381]=3; image[16382]=3; image[16383]=1; image[16384]=2; image[16385]=1; image[16386]=1; image[16387]=1; image[16388]=1; image[16389]=1; image[16390]=1; image[16391]=1; image[16392]=1; image[16393]=1; image[16394]=1; image[16395]=1; image[16396]=7; image[16397]=9; image[16398]=10; image[16399]=10; image[16400]=8; image[16401]=14; image[16402]=17; image[16403]=11; image[16404]=5; image[16405]=11; image[16406]=13; image[16407]=12; image[16408]=10; image[16409]=8; image[16410]=6; image[16411]=8; image[16412]=8; image[16413]=10; image[16414]=15; image[16415]=10; image[16416]=12; image[16417]=14; image[16418]=16; image[16419]=25; image[16420]=34; image[16421]=37; image[16422]=41; image[16423]=38; image[16424]=39; image[16425]=42; image[16426]=37; image[16427]=34; image[16428]=19; image[16429]=11; image[16430]=37; image[16431]=51; image[16432]=53; image[16433]=40; image[16434]=34; image[16435]=45; image[16436]=117; image[16437]=143; image[16438]=146; image[16439]=118; image[16440]=125; image[16441]=176; image[16442]=109; image[16443]=16; image[16444]=50; image[16445]=66; image[16446]=47; image[16447]=29; image[16448]=47; image[16449]=123; image[16450]=128; image[16451]=176; image[16452]=242; image[16453]=255; image[16454]=239; image[16455]=234; image[16456]=245; image[16457]=255; image[16458]=236; image[16459]=246; image[16460]=255; image[16461]=255; image[16462]=250; image[16463]=235; image[16464]=171; image[16465]=101; image[16466]=40; image[16467]=43; image[16468]=125; image[16469]=255; image[16470]=255; image[16471]=117; image[16472]=123; image[16473]=78; image[16474]=26; image[16475]=10; image[16476]=2; image[16477]=1; image[16478]=1; image[16479]=1; image[16480]=1; image[16481]=1; image[16482]=1; image[16483]=1; image[16484]=1; image[16485]=1; image[16486]=1; image[16487]=1; image[16488]=1; image[16489]=1; image[16490]=1; image[16491]=1; image[16492]=1; image[16493]=1; image[16494]=1; image[16495]=1; image[16496]=1; image[16497]=1; image[16498]=1; image[16499]=1; image[16500]=1; image[16501]=1; image[16502]=1; image[16503]=1; image[16504]=1; image[16505]=1; image[16506]=1; image[16507]=1; image[16508]=1; image[16509]=1; image[16510]=1; image[16511]=1; image[16512]=1; image[16513]=1; image[16514]=1; image[16515]=1; image[16516]=1; image[16517]=1; image[16518]=1; image[16519]=1; image[16520]=1; image[16521]=1; image[16522]=1; image[16523]=1; image[16524]=1; image[16525]=1; image[16526]=1; image[16527]=1; image[16528]=1; image[16529]=1; image[16530]=1; image[16531]=1; image[16532]=1; image[16533]=1; image[16534]=1; image[16535]=1; image[16536]=1; image[16537]=1; image[16538]=1; image[16539]=1; image[16540]=1; image[16541]=1; image[16542]=1; image[16543]=1; image[16544]=1; image[16545]=1; image[16546]=1; image[16547]=1; image[16548]=1; image[16549]=1; image[16550]=1; image[16551]=1; image[16552]=1; image[16553]=1; image[16554]=1; image[16555]=1; image[16556]=1; image[16557]=1; image[16558]=1; image[16559]=1; image[16560]=1; image[16561]=1; image[16562]=1; image[16563]=1; image[16564]=1; image[16565]=1; image[16566]=1; image[16567]=1; image[16568]=1; image[16569]=1; image[16570]=1; image[16571]=1; image[16572]=1; image[16573]=1; image[16574]=1; image[16575]=1; image[16576]=1; image[16577]=1; image[16578]=1; image[16579]=2; image[16580]=3; image[16581]=3; image[16582]=3; image[16583]=1; image[16584]=1; image[16585]=1; image[16586]=1; image[16587]=1; image[16588]=1; image[16589]=1; image[16590]=1; image[16591]=1; image[16592]=1; image[16593]=1; image[16594]=1; image[16595]=6; image[16596]=9; image[16597]=9; image[16598]=12; image[16599]=8; image[16600]=11; image[16601]=16; image[16602]=12; image[16603]=4; image[16604]=9; image[16605]=11; image[16606]=9; image[16607]=9; image[16608]=8; image[16609]=7; image[16610]=10; image[16611]=8; image[16612]=9; image[16613]=10; image[16614]=8; image[16615]=12; image[16616]=16; image[16617]=22; image[16618]=27; image[16619]=28; image[16620]=30; image[16621]=37; image[16622]=44; image[16623]=46; image[16624]=58; image[16625]=64; image[16626]=58; image[16627]=30; image[16628]=12; image[16629]=34; image[16630]=53; image[16631]=51; image[16632]=37; image[16633]=34; image[16634]=36; image[16635]=101; image[16636]=142; image[16637]=146; image[16638]=140; image[16639]=143; image[16640]=218; image[16641]=166; image[16642]=26; image[16643]=73; image[16644]=95; image[16645]=102; image[16646]=89; image[16647]=53; image[16648]=52; image[16649]=93; image[16650]=146; image[16651]=191; image[16652]=251; image[16653]=252; image[16654]=242; image[16655]=201; image[16656]=193; image[16657]=229; image[16658]=253; image[16659]=255; image[16660]=255; image[16661]=255; image[16662]=255; image[16663]=152; image[16664]=59; image[16665]=33; image[16666]=41; image[16667]=154; image[16668]=255; image[16669]=255; image[16670]=107; image[16671]=221; image[16672]=97; image[16673]=24; image[16674]=8; image[16675]=2; image[16676]=1; image[16677]=1; image[16678]=1; image[16679]=1; image[16680]=1; image[16681]=1; image[16682]=1; image[16683]=1; image[16684]=1; image[16685]=1; image[16686]=1; image[16687]=1; image[16688]=1; image[16689]=1; image[16690]=1; image[16691]=1; image[16692]=1; image[16693]=1; image[16694]=1; image[16695]=1; image[16696]=1; image[16697]=1; image[16698]=1; image[16699]=1; image[16700]=1; image[16701]=1; image[16702]=1; image[16703]=1; image[16704]=1; image[16705]=1; image[16706]=1; image[16707]=1; image[16708]=1; image[16709]=1; image[16710]=1; image[16711]=1; image[16712]=1; image[16713]=1; image[16714]=1; image[16715]=1; image[16716]=1; image[16717]=1; image[16718]=1; image[16719]=1; image[16720]=1; image[16721]=1; image[16722]=1; image[16723]=1; image[16724]=1; image[16725]=2; image[16726]=1; image[16727]=1; image[16728]=1; image[16729]=1; image[16730]=1; image[16731]=1; image[16732]=1; image[16733]=1; image[16734]=1; image[16735]=1; image[16736]=1; image[16737]=1; image[16738]=1; image[16739]=1; image[16740]=1; image[16741]=1; image[16742]=1; image[16743]=1; image[16744]=1; image[16745]=1; image[16746]=1; image[16747]=1; image[16748]=1; image[16749]=1; image[16750]=1; image[16751]=1; image[16752]=1; image[16753]=1; image[16754]=1; image[16755]=1; image[16756]=1; image[16757]=1; image[16758]=1; image[16759]=1; image[16760]=1; image[16761]=1; image[16762]=1; image[16763]=1; image[16764]=1; image[16765]=1; image[16766]=1; image[16767]=1; image[16768]=1; image[16769]=1; image[16770]=1; image[16771]=1; image[16772]=1; image[16773]=1; image[16774]=1; image[16775]=1; image[16776]=1; image[16777]=1; image[16778]=2; image[16779]=2; image[16780]=3; image[16781]=3; image[16782]=2; image[16783]=1; image[16784]=1; image[16785]=1; image[16786]=1; image[16787]=1; image[16788]=1; image[16789]=1; image[16790]=1; image[16791]=1; image[16792]=1; image[16793]=1; image[16794]=6; image[16795]=9; image[16796]=9; image[16797]=13; image[16798]=10; image[16799]=9; image[16800]=17; image[16801]=15; image[16802]=4; image[16803]=8; image[16804]=9; image[16805]=5; image[16806]=5; image[16807]=8; image[16808]=17; image[16809]=19; image[16810]=11; image[16811]=12; image[16812]=14; image[16813]=13; image[16814]=17; image[16815]=21; image[16816]=29; image[16817]=30; image[16818]=31; image[16819]=30; image[16820]=37; image[16821]=56; image[16822]=55; image[16823]=52; image[16824]=69; image[16825]=75; image[16826]=36; image[16827]=12; image[16828]=32; image[16829]=56; image[16830]=50; image[16831]=34; image[16832]=34; image[16833]=34; image[16834]=92; image[16835]=147; image[16836]=151; image[16837]=140; image[16838]=137; image[16839]=222; image[16840]=205; image[16841]=37; image[16842]=77; image[16843]=115; image[16844]=116; image[16845]=124; image[16846]=102; image[16847]=45; image[16848]=37; image[16849]=113; image[16850]=219; image[16851]=255; image[16852]=255; image[16853]=255; image[16854]=249; image[16855]=221; image[16856]=229; image[16857]=255; image[16858]=255; image[16859]=255; image[16860]=255; image[16861]=255; image[16862]=175; image[16863]=43; image[16864]=33; image[16865]=46; image[16866]=187; image[16867]=255; image[16868]=255; image[16869]=113; image[16870]=236; image[16871]=86; image[16872]=19; image[16873]=7; image[16874]=2; image[16875]=1; image[16876]=1; image[16877]=1; image[16878]=1; image[16879]=1; image[16880]=1; image[16881]=1; image[16882]=1; image[16883]=1; image[16884]=1; image[16885]=1; image[16886]=1; image[16887]=1; image[16888]=1; image[16889]=1; image[16890]=1; image[16891]=1; image[16892]=1; image[16893]=1; image[16894]=1; image[16895]=1; image[16896]=1; image[16897]=1; image[16898]=1; image[16899]=1; image[16900]=1; image[16901]=1; image[16902]=1; image[16903]=1; image[16904]=1; image[16905]=1; image[16906]=1; image[16907]=1; image[16908]=1; image[16909]=1; image[16910]=1; image[16911]=1; image[16912]=1; image[16913]=1; image[16914]=1; image[16915]=1; image[16916]=1; image[16917]=1; image[16918]=1; image[16919]=1; image[16920]=1; image[16921]=1; image[16922]=1; image[16923]=1; image[16924]=1; image[16925]=1; image[16926]=1; image[16927]=1; image[16928]=1; image[16929]=1; image[16930]=1; image[16931]=1; image[16932]=1; image[16933]=1; image[16934]=1; image[16935]=1; image[16936]=1; image[16937]=1; image[16938]=1; image[16939]=1; image[16940]=1; image[16941]=1; image[16942]=1; image[16943]=1; image[16944]=1; image[16945]=1; image[16946]=1; image[16947]=1; image[16948]=1; image[16949]=1; image[16950]=1; image[16951]=1; image[16952]=1; image[16953]=1; image[16954]=1; image[16955]=1; image[16956]=1; image[16957]=1; image[16958]=1; image[16959]=1; image[16960]=1; image[16961]=1; image[16962]=1; image[16963]=1; image[16964]=1; image[16965]=1; image[16966]=1; image[16967]=1; image[16968]=1; image[16969]=1; image[16970]=1; image[16971]=1; image[16972]=1; image[16973]=1; image[16974]=1; image[16975]=1; image[16976]=2; image[16977]=2; image[16978]=2; image[16979]=3; image[16980]=3; image[16981]=3; image[16982]=1; image[16983]=1; image[16984]=1; image[16985]=1; image[16986]=1; image[16987]=1; image[16988]=1; image[16989]=1; image[16990]=1; image[16991]=1; image[16992]=1; image[16993]=6; image[16994]=8; image[16995]=8; image[16996]=11; image[16997]=11; image[16998]=9; image[16999]=16; image[17000]=16; image[17001]=4; image[17002]=3; image[17003]=3; image[17004]=5; image[17005]=14; image[17006]=27; image[17007]=19; image[17008]=12; image[17009]=14; image[17010]=21; image[17011]=24; image[17012]=17; image[17013]=18; image[17014]=21; image[17015]=31; image[17016]=32; image[17017]=35; image[17018]=36; image[17019]=38; image[17020]=52; image[17021]=62; image[17022]=61; image[17023]=49; image[17024]=51; image[17025]=38; image[17026]=13; image[17027]=21; image[17028]=46; image[17029]=48; image[17030]=35; image[17031]=34; image[17032]=39; image[17033]=77; image[17034]=129; image[17035]=132; image[17036]=99; image[17037]=109; image[17038]=197; image[17039]=191; image[17040]=48; image[17041]=43; image[17042]=101; image[17043]=102; image[17044]=115; image[17045]=112; image[17046]=112; image[17047]=72; image[17048]=46; image[17049]=95; image[17050]=207; image[17051]=254; image[17052]=255; image[17053]=255; image[17054]=255; image[17055]=255; image[17056]=255; image[17057]=255; image[17058]=255; image[17059]=255; image[17060]=255; image[17061]=235; image[17062]=54; image[17063]=36; image[17064]=104; image[17065]=232; image[17066]=255; image[17067]=255; image[17068]=176; image[17069]=148; image[17070]=60; image[17071]=19; image[17072]=7; image[17073]=2; image[17074]=1; image[17075]=1; image[17076]=1; image[17077]=1; image[17078]=1; image[17079]=1; image[17080]=1; image[17081]=1; image[17082]=1; image[17083]=1; image[17084]=1; image[17085]=1; image[17086]=1; image[17087]=1; image[17088]=1; image[17089]=1; image[17090]=1; image[17091]=1; image[17092]=1; image[17093]=1; image[17094]=1; image[17095]=1; image[17096]=1; image[17097]=1; image[17098]=1; image[17099]=1; image[17100]=1; image[17101]=1; image[17102]=1; image[17103]=1; image[17104]=1; image[17105]=1; image[17106]=1; image[17107]=1; image[17108]=1; image[17109]=1; image[17110]=1; image[17111]=1; image[17112]=1; image[17113]=1; image[17114]=1; image[17115]=1; image[17116]=1; image[17117]=1; image[17118]=1; image[17119]=1; image[17120]=1; image[17121]=1; image[17122]=1; image[17123]=1; image[17124]=1; image[17125]=1; image[17126]=1; image[17127]=1; image[17128]=1; image[17129]=1; image[17130]=1; image[17131]=1; image[17132]=1; image[17133]=1; image[17134]=1; image[17135]=1; image[17136]=1; image[17137]=1; image[17138]=1; image[17139]=1; image[17140]=1; image[17141]=1; image[17142]=1; image[17143]=1; image[17144]=1; image[17145]=1; image[17146]=1; image[17147]=1; image[17148]=1; image[17149]=1; image[17150]=1; image[17151]=1; image[17152]=1; image[17153]=1; image[17154]=1; image[17155]=1; image[17156]=1; image[17157]=1; image[17158]=1; image[17159]=1; image[17160]=1; image[17161]=1; image[17162]=1; image[17163]=1; image[17164]=1; image[17165]=1; image[17166]=1; image[17167]=1; image[17168]=1; image[17169]=1; image[17170]=1; image[17171]=1; image[17172]=1; image[17173]=1; image[17174]=1; image[17175]=2; image[17176]=2; image[17177]=2; image[17178]=3; image[17179]=3; image[17180]=3; image[17181]=2; image[17182]=2; image[17183]=1; image[17184]=1; image[17185]=1; image[17186]=1; image[17187]=1; image[17188]=1; image[17189]=1; image[17190]=1; image[17191]=1; image[17192]=5; image[17193]=8; image[17194]=9; image[17195]=11; image[17196]=10; image[17197]=8; image[17198]=14; image[17199]=16; image[17200]=6; image[17201]=4; image[17202]=4; image[17203]=9; image[17204]=18; image[17205]=22; image[17206]=11; image[17207]=12; image[17208]=19; image[17209]=24; image[17210]=27; image[17211]=21; image[17212]=22; image[17213]=27; image[17214]=32; image[17215]=30; image[17216]=32; image[17217]=33; image[17218]=36; image[17219]=47; image[17220]=57; image[17221]=58; image[17222]=53; image[17223]=54; image[17224]=27; image[17225]=9; image[17226]=21; image[17227]=44; image[17228]=48; image[17229]=36; image[17230]=32; image[17231]=42; image[17232]=68; image[17233]=119; image[17234]=130; image[17235]=105; image[17236]=113; image[17237]=218; image[17238]=216; image[17239]=85; image[17240]=24; image[17241]=61; image[17242]=90; image[17243]=126; image[17244]=137; image[17245]=136; image[17246]=110; image[17247]=64; image[17248]=59; image[17249]=126; image[17250]=217; image[17251]=248; image[17252]=255; image[17253]=255; image[17254]=255; image[17255]=255; image[17256]=255; image[17257]=255; image[17258]=255; image[17259]=255; image[17260]=232; image[17261]=53; image[17262]=58; image[17263]=178; image[17264]=253; image[17265]=255; image[17266]=255; image[17267]=193; image[17268]=172; image[17269]=72; image[17270]=22; image[17271]=7; image[17272]=2; image[17273]=1; image[17274]=1; image[17275]=1; image[17276]=1; image[17277]=1; image[17278]=1; image[17279]=1; image[17280]=1; image[17281]=1; image[17282]=1; image[17283]=1; image[17284]=1; image[17285]=1; image[17286]=1; image[17287]=1; image[17288]=1; image[17289]=1; image[17290]=1; image[17291]=1; image[17292]=1; image[17293]=1; image[17294]=1; image[17295]=1; image[17296]=1; image[17297]=1; image[17298]=1; image[17299]=1; image[17300]=1; image[17301]=1; image[17302]=1; image[17303]=1; image[17304]=1; image[17305]=1; image[17306]=1; image[17307]=1; image[17308]=1; image[17309]=1; image[17310]=1; image[17311]=1; image[17312]=1; image[17313]=1; image[17314]=2; image[17315]=1; image[17316]=1; image[17317]=1; image[17318]=1; image[17319]=1; image[17320]=1; image[17321]=1; image[17322]=1; image[17323]=1; image[17324]=1; image[17325]=1; image[17326]=1; image[17327]=1; image[17328]=1; image[17329]=1; image[17330]=1; image[17331]=1; image[17332]=1; image[17333]=1; image[17334]=1; image[17335]=1; image[17336]=1; image[17337]=1; image[17338]=1; image[17339]=1; image[17340]=1; image[17341]=1; image[17342]=1; image[17343]=1; image[17344]=1; image[17345]=1; image[17346]=1; image[17347]=1; image[17348]=1; image[17349]=1; image[17350]=1; image[17351]=1; image[17352]=1; image[17353]=1; image[17354]=1; image[17355]=1; image[17356]=1; image[17357]=1; image[17358]=1; image[17359]=1; image[17360]=1; image[17361]=1; image[17362]=1; image[17363]=1; image[17364]=1; image[17365]=1; image[17366]=1; image[17367]=1; image[17368]=1; image[17369]=1; image[17370]=1; image[17371]=1; image[17372]=1; image[17373]=1; image[17374]=1; image[17375]=1; image[17376]=2; image[17377]=4; image[17378]=4; image[17379]=4; image[17380]=4; image[17381]=3; image[17382]=3; image[17383]=1; image[17384]=1; image[17385]=1; image[17386]=1; image[17387]=1; image[17388]=1; image[17389]=1; image[17390]=1; image[17391]=5; image[17392]=8; image[17393]=9; image[17394]=12; image[17395]=10; image[17396]=10; image[17397]=15; image[17398]=18; image[17399]=7; image[17400]=4; image[17401]=3; image[17402]=4; image[17403]=7; image[17404]=8; image[17405]=11; image[17406]=18; image[17407]=21; image[17408]=26; image[17409]=29; image[17410]=27; image[17411]=27; image[17412]=31; image[17413]=31; image[17414]=28; image[17415]=34; image[17416]=33; image[17417]=35; image[17418]=44; image[17419]=53; image[17420]=55; image[17421]=57; image[17422]=68; image[17423]=29; image[17424]=6; image[17425]=21; image[17426]=40; image[17427]=50; image[17428]=37; image[17429]=34; image[17430]=45; image[17431]=55; image[17432]=108; image[17433]=133; image[17434]=136; image[17435]=138; image[17436]=237; image[17437]=255; image[17438]=197; image[17439]=27; image[17440]=37; image[17441]=100; image[17442]=134; image[17443]=165; image[17444]=159; image[17445]=149; image[17446]=92; image[17447]=64; image[17448]=78; image[17449]=126; image[17450]=197; image[17451]=255; image[17452]=255; image[17453]=255; image[17454]=255; image[17455]=255; image[17456]=255; image[17457]=255; image[17458]=255; image[17459]=230; image[17460]=51; image[17461]=93; image[17462]=252; image[17463]=255; image[17464]=255; image[17465]=255; image[17466]=218; image[17467]=241; image[17468]=96; image[17469]=26; image[17470]=10; image[17471]=1; image[17472]=1; image[17473]=1; image[17474]=1; image[17475]=1; image[17476]=1; image[17477]=1; image[17478]=1; image[17479]=1; image[17480]=1; image[17481]=1; image[17482]=1; image[17483]=1; image[17484]=1; image[17485]=1; image[17486]=1; image[17487]=1; image[17488]=1; image[17489]=1; image[17490]=1; image[17491]=1; image[17492]=1; image[17493]=1; image[17494]=1; image[17495]=1; image[17496]=1; image[17497]=1; image[17498]=1; image[17499]=1; image[17500]=1; image[17501]=1; image[17502]=1; image[17503]=1; image[17504]=1; image[17505]=1; image[17506]=1; image[17507]=1; image[17508]=1; image[17509]=1; image[17510]=1; image[17511]=1; image[17512]=1; image[17513]=1; image[17514]=1; image[17515]=1; image[17516]=1; image[17517]=1; image[17518]=1; image[17519]=1; image[17520]=1; image[17521]=1; image[17522]=1; image[17523]=1; image[17524]=1; image[17525]=1; image[17526]=1; image[17527]=1; image[17528]=1; image[17529]=1; image[17530]=1; image[17531]=1; image[17532]=1; image[17533]=1; image[17534]=1; image[17535]=1; image[17536]=1; image[17537]=1; image[17538]=1; image[17539]=1; image[17540]=1; image[17541]=1; image[17542]=1; image[17543]=1; image[17544]=1; image[17545]=1; image[17546]=1; image[17547]=1; image[17548]=1; image[17549]=1; image[17550]=1; image[17551]=1; image[17552]=1; image[17553]=1; image[17554]=1; image[17555]=1; image[17556]=1; image[17557]=1; image[17558]=1; image[17559]=1; image[17560]=1; image[17561]=1; image[17562]=1; image[17563]=1; image[17564]=1; image[17565]=1; image[17566]=1; image[17567]=1; image[17568]=1; image[17569]=1; image[17570]=1; image[17571]=1; image[17572]=1; image[17573]=1; image[17574]=1; image[17575]=3; image[17576]=4; image[17577]=4; image[17578]=4; image[17579]=5; image[17580]=4; image[17581]=4; image[17582]=2; image[17583]=1; image[17584]=1; image[17585]=1; image[17586]=1; image[17587]=1; image[17588]=1; image[17589]=1; image[17590]=4; image[17591]=7; image[17592]=7; image[17593]=10; image[17594]=11; image[17595]=7; image[17596]=14; image[17597]=18; image[17598]=13; image[17599]=5; image[17600]=4; image[17601]=5; image[17602]=8; image[17603]=15; image[17604]=16; image[17605]=19; image[17606]=19; image[17607]=21; image[17608]=22; image[17609]=24; image[17610]=25; image[17611]=24; image[17612]=24; image[17613]=27; image[17614]=30; image[17615]=33; image[17616]=36; image[17617]=41; image[17618]=42; image[17619]=48; image[17620]=46; image[17621]=46; image[17622]=28; image[17623]=6; image[17624]=21; image[17625]=40; image[17626]=51; image[17627]=42; image[17628]=34; image[17629]=43; image[17630]=56; image[17631]=115; image[17632]=140; image[17633]=147; image[17634]=151; image[17635]=213; image[17636]=255; image[17637]=255; image[17638]=42; image[17639]=22; image[17640]=110; image[17641]=137; image[17642]=148; image[17643]=159; image[17644]=178; image[17645]=141; image[17646]=80; image[17647]=67; image[17648]=100; image[17649]=123; image[17650]=150; image[17651]=230; image[17652]=255; image[17653]=255; image[17654]=255; image[17655]=255; image[17656]=255; image[17657]=255; image[17658]=228; image[17659]=54; image[17660]=112; image[17661]=251; image[17662]=255; image[17663]=255; image[17664]=255; image[17665]=216; image[17666]=239; image[17667]=109; image[17668]=22; image[17669]=6; image[17670]=2; image[17671]=1; image[17672]=1; image[17673]=1; image[17674]=1; image[17675]=1; image[17676]=1; image[17677]=1; image[17678]=1; image[17679]=1; image[17680]=1; image[17681]=1; image[17682]=1; image[17683]=1; image[17684]=1; image[17685]=1; image[17686]=1; image[17687]=1; image[17688]=1; image[17689]=1; image[17690]=1; image[17691]=1; image[17692]=1; image[17693]=1; image[17694]=1; image[17695]=1; image[17696]=1; image[17697]=1; image[17698]=1; image[17699]=1; image[17700]=1; image[17701]=1; image[17702]=1; image[17703]=1; image[17704]=1; image[17705]=1; image[17706]=1; image[17707]=1; image[17708]=1; image[17709]=1; image[17710]=1; image[17711]=1; image[17712]=1; image[17713]=1; image[17714]=1; image[17715]=1; image[17716]=1; image[17717]=1; image[17718]=1; image[17719]=1; image[17720]=1; image[17721]=1; image[17722]=1; image[17723]=1; image[17724]=1; image[17725]=1; image[17726]=1; image[17727]=1; image[17728]=1; image[17729]=1; image[17730]=1; image[17731]=1; image[17732]=1; image[17733]=1; image[17734]=1; image[17735]=1; image[17736]=1; image[17737]=1; image[17738]=1; image[17739]=2; image[17740]=2; image[17741]=1; image[17742]=1; image[17743]=1; image[17744]=1; image[17745]=1; image[17746]=1; image[17747]=1; image[17748]=1; image[17749]=1; image[17750]=1; image[17751]=1; image[17752]=1; image[17753]=1; image[17754]=1; image[17755]=1; image[17756]=1; image[17757]=1; image[17758]=1; image[17759]=1; image[17760]=1; image[17761]=1; image[17762]=1; image[17763]=1; image[17764]=1; image[17765]=1; image[17766]=1; image[17767]=1; image[17768]=1; image[17769]=1; image[17770]=1; image[17771]=1; image[17772]=1; image[17773]=2; image[17774]=2; image[17775]=4; image[17776]=5; image[17777]=5; image[17778]=6; image[17779]=4; image[17780]=4; image[17781]=2; image[17782]=1; image[17783]=1; image[17784]=1; image[17785]=1; image[17786]=1; image[17787]=1; image[17788]=1; image[17789]=5; image[17790]=8; image[17791]=7; image[17792]=9; image[17793]=10; image[17794]=7; image[17795]=13; image[17796]=17; image[17797]=16; image[17798]=7; image[17799]=8; image[17800]=10; image[17801]=14; image[17802]=16; image[17803]=13; image[17804]=13; image[17805]=15; image[17806]=17; image[17807]=18; image[17808]=21; image[17809]=23; image[17810]=21; image[17811]=20; image[17812]=27; image[17813]=31; image[17814]=32; image[17815]=28; image[17816]=35; image[17817]=39; image[17818]=39; image[17819]=37; image[17820]=35; image[17821]=24; image[17822]=7; image[17823]=19; image[17824]=38; image[17825]=50; image[17826]=42; image[17827]=33; image[17828]=45; image[17829]=59; image[17830]=109; image[17831]=142; image[17832]=139; image[17833]=145; image[17834]=187; image[17835]=250; image[17836]=255; image[17837]=51; image[17838]=9; image[17839]=76; image[17840]=116; image[17841]=133; image[17842]=155; image[17843]=180; image[17844]=162; image[17845]=97; image[17846]=71; image[17847]=91; image[17848]=107; image[17849]=125; image[17850]=214; image[17851]=255; image[17852]=255; image[17853]=255; image[17854]=255; image[17855]=255; image[17856]=255; image[17857]=217; image[17858]=62; image[17859]=127; image[17860]=252; image[17861]=255; image[17862]=255; image[17863]=255; image[17864]=203; image[17865]=198; image[17866]=94; image[17867]=26; image[17868]=7; image[17869]=2; image[17870]=1; image[17871]=1; image[17872]=1; image[17873]=1; image[17874]=1; image[17875]=1; image[17876]=1; image[17877]=1; image[17878]=1; image[17879]=1; image[17880]=1; image[17881]=1; image[17882]=1; image[17883]=1; image[17884]=1; image[17885]=1; image[17886]=1; image[17887]=1; image[17888]=1; image[17889]=1; image[17890]=1; image[17891]=1; image[17892]=1; image[17893]=1; image[17894]=1; image[17895]=1; image[17896]=1; image[17897]=1; image[17898]=1; image[17899]=1; image[17900]=1; image[17901]=1; image[17902]=1; image[17903]=1; image[17904]=1; image[17905]=1; image[17906]=1; image[17907]=1; image[17908]=1; image[17909]=1; image[17910]=1; image[17911]=1; image[17912]=1; image[17913]=1; image[17914]=1; image[17915]=1; image[17916]=1; image[17917]=1; image[17918]=1; image[17919]=1; image[17920]=1; image[17921]=1; image[17922]=1; image[17923]=1; image[17924]=1; image[17925]=1; image[17926]=1; image[17927]=1; image[17928]=1; image[17929]=1; image[17930]=1; image[17931]=1; image[17932]=1; image[17933]=1; image[17934]=1; image[17935]=1; image[17936]=1; image[17937]=1; image[17938]=1; image[17939]=2; image[17940]=1; image[17941]=1; image[17942]=1; image[17943]=1; image[17944]=1; image[17945]=1; image[17946]=1; image[17947]=1; image[17948]=1; image[17949]=1; image[17950]=1; image[17951]=1; image[17952]=1; image[17953]=1; image[17954]=1; image[17955]=1; image[17956]=1; image[17957]=1; image[17958]=1; image[17959]=1; image[17960]=1; image[17961]=1; image[17962]=1; image[17963]=1; image[17964]=1; image[17965]=1; image[17966]=1; image[17967]=1; image[17968]=1; image[17969]=1; image[17970]=1; image[17971]=1; image[17972]=1; image[17973]=3; image[17974]=3; image[17975]=6; image[17976]=6; image[17977]=4; image[17978]=3; image[17979]=3; image[17980]=4; image[17981]=2; image[17982]=1; image[17983]=1; image[17984]=1; image[17985]=1; image[17986]=1; image[17987]=2; image[17988]=4; image[17989]=7; image[17990]=7; image[17991]=8; image[17992]=9; image[17993]=7; image[17994]=11; image[17995]=16; image[17996]=18; image[17997]=7; image[17998]=8; image[17999]=12; image[18000]=13; image[18001]=10; image[18002]=10; image[18003]=10; image[18004]=10; image[18005]=11; image[18006]=10; image[18007]=9; image[18008]=9; image[18009]=9; image[18010]=10; image[18011]=9; image[18012]=9; image[18013]=11; image[18014]=10; image[18015]=15; image[18016]=22; image[18017]=25; image[18018]=27; image[18019]=34; image[18020]=30; image[18021]=9; image[18022]=15; image[18023]=29; image[18024]=43; image[18025]=44; image[18026]=34; image[18027]=52; image[18028]=69; image[18029]=98; image[18030]=153; image[18031]=129; image[18032]=134; image[18033]=150; image[18034]=207; image[18035]=255; image[18036]=95; image[18037]=0; image[18038]=21; image[18039]=84; image[18040]=136; image[18041]=173; image[18042]=175; image[18043]=154; image[18044]=139; image[18045]=108; image[18046]=94; image[18047]=99; image[18048]=125; image[18049]=183; image[18050]=246; image[18051]=255; image[18052]=255; image[18053]=255; image[18054]=255; image[18055]=255; image[18056]=167; image[18057]=80; image[18058]=162; image[18059]=253; image[18060]=255; image[18061]=255; image[18062]=255; image[18063]=224; image[18064]=228; image[18065]=68; image[18066]=27; image[18067]=5; image[18068]=2; image[18069]=1; image[18070]=1; image[18071]=1; image[18072]=1; image[18073]=1; image[18074]=1; image[18075]=1; image[18076]=1; image[18077]=1; image[18078]=1; image[18079]=1; image[18080]=1; image[18081]=1; image[18082]=1; image[18083]=1; image[18084]=1; image[18085]=1; image[18086]=1; image[18087]=1; image[18088]=1; image[18089]=2; image[18090]=1; image[18091]=1; image[18092]=1; image[18093]=1; image[18094]=1; image[18095]=1; image[18096]=1; image[18097]=1; image[18098]=1; image[18099]=1; image[18100]=1; image[18101]=1; image[18102]=1; image[18103]=1; image[18104]=1; image[18105]=1; image[18106]=1; image[18107]=1; image[18108]=1; image[18109]=1; image[18110]=1; image[18111]=1; image[18112]=1; image[18113]=1; image[18114]=1; image[18115]=1; image[18116]=1; image[18117]=1; image[18118]=1; image[18119]=1; image[18120]=1; image[18121]=1; image[18122]=1; image[18123]=1; image[18124]=1; image[18125]=1; image[18126]=1; image[18127]=1; image[18128]=1; image[18129]=1; image[18130]=1; image[18131]=1; image[18132]=1; image[18133]=1; image[18134]=1; image[18135]=1; image[18136]=1; image[18137]=1; image[18138]=2; image[18139]=1; image[18140]=1; image[18141]=1; image[18142]=1; image[18143]=1; image[18144]=1; image[18145]=1; image[18146]=1; image[18147]=1; image[18148]=1; image[18149]=1; image[18150]=1; image[18151]=1; image[18152]=1; image[18153]=1; image[18154]=1; image[18155]=1; image[18156]=1; image[18157]=1; image[18158]=1; image[18159]=1; image[18160]=1; image[18161]=1; image[18162]=1; image[18163]=1; image[18164]=1; image[18165]=1; image[18166]=1; image[18167]=1; image[18168]=1; image[18169]=1; image[18170]=1; image[18171]=1; image[18172]=2; image[18173]=3; image[18174]=5; image[18175]=5; image[18176]=4; image[18177]=4; image[18178]=4; image[18179]=6; image[18180]=3; image[18181]=1; image[18182]=1; image[18183]=1; image[18184]=1; image[18185]=1; image[18186]=2; image[18187]=4; image[18188]=6; image[18189]=8; image[18190]=7; image[18191]=10; image[18192]=8; image[18193]=11; image[18194]=15; image[18195]=17; image[18196]=8; image[18197]=5; image[18198]=9; image[18199]=10; image[18200]=8; image[18201]=10; image[18202]=10; image[18203]=8; image[18204]=9; image[18205]=10; image[18206]=10; image[18207]=9; image[18208]=9; image[18209]=11; image[18210]=10; image[18211]=13; image[18212]=11; image[18213]=11; image[18214]=12; image[18215]=14; image[18216]=15; image[18217]=14; image[18218]=13; image[18219]=11; image[18220]=8; image[18221]=17; image[18222]=29; image[18223]=41; image[18224]=43; image[18225]=36; image[18226]=51; image[18227]=71; image[18228]=90; image[18229]=149; image[18230]=122; image[18231]=129; image[18232]=166; image[18233]=207; image[18234]=255; image[18235]=117; image[18236]=0; image[18237]=8; image[18238]=61; image[18239]=147; image[18240]=182; image[18241]=187; image[18242]=171; image[18243]=154; image[18244]=135; image[18245]=109; image[18246]=95; image[18247]=107; image[18248]=151; image[18249]=233; image[18250]=255; image[18251]=255; image[18252]=255; image[18253]=255; image[18254]=255; image[18255]=133; image[18256]=104; image[18257]=165; image[18258]=253; image[18259]=255; image[18260]=255; image[18261]=255; image[18262]=198; image[18263]=237; image[18264]=72; image[18265]=25; image[18266]=4; image[18267]=2; image[18268]=1; image[18269]=1; image[18270]=1; image[18271]=1; image[18272]=1; image[18273]=1; image[18274]=1; image[18275]=1; image[18276]=1; image[18277]=1; image[18278]=1; image[18279]=1; image[18280]=1; image[18281]=1; image[18282]=1; image[18283]=1; image[18284]=1; image[18285]=1; image[18286]=1; image[18287]=1; image[18288]=1; image[18289]=1; image[18290]=1; image[18291]=1; image[18292]=1; image[18293]=1; image[18294]=1; image[18295]=1; image[18296]=1; image[18297]=1; image[18298]=1; image[18299]=1; image[18300]=1; image[18301]=1; image[18302]=1; image[18303]=1; image[18304]=1; image[18305]=1; image[18306]=1; image[18307]=1; image[18308]=1; image[18309]=1; image[18310]=1; image[18311]=1; image[18312]=1; image[18313]=1; image[18314]=1; image[18315]=1; image[18316]=1; image[18317]=1; image[18318]=1; image[18319]=1; image[18320]=1; image[18321]=1; image[18322]=1; image[18323]=1; image[18324]=1; image[18325]=1; image[18326]=1; image[18327]=1; image[18328]=1; image[18329]=1; image[18330]=1; image[18331]=1; image[18332]=1; image[18333]=1; image[18334]=1; image[18335]=1; image[18336]=1; image[18337]=2; image[18338]=1; image[18339]=1; image[18340]=1; image[18341]=1; image[18342]=1; image[18343]=1; image[18344]=1; image[18345]=1; image[18346]=1; image[18347]=1; image[18348]=1; image[18349]=1; image[18350]=1; image[18351]=1; image[18352]=1; image[18353]=1; image[18354]=1; image[18355]=1; image[18356]=1; image[18357]=1; image[18358]=1; image[18359]=1; image[18360]=1; image[18361]=1; image[18362]=1; image[18363]=1; image[18364]=1; image[18365]=1; image[18366]=1; image[18367]=1; image[18368]=1; image[18369]=1; image[18370]=1; image[18371]=2; image[18372]=3; image[18373]=4; image[18374]=4; image[18375]=5; image[18376]=5; image[18377]=6; image[18378]=8; image[18379]=5; image[18380]=2; image[18381]=1; image[18382]=1; image[18383]=1; image[18384]=1; image[18385]=2; image[18386]=3; image[18387]=5; image[18388]=7; image[18389]=7; image[18390]=10; image[18391]=8; image[18392]=9; image[18393]=14; image[18394]=14; image[18395]=8; image[18396]=5; image[18397]=8; image[18398]=9; image[18399]=6; image[18400]=7; image[18401]=7; image[18402]=7; image[18403]=6; image[18404]=7; image[18405]=7; image[18406]=8; image[18407]=12; image[18408]=16; image[18409]=23; image[18410]=31; image[18411]=25; image[18412]=27; image[18413]=22; image[18414]=14; image[18415]=9; image[18416]=5; image[18417]=3; image[18418]=4; image[18419]=7; image[18420]=19; image[18421]=32; image[18422]=41; image[18423]=39; image[18424]=37; image[18425]=47; image[18426]=72; image[18427]=87; image[18428]=145; image[18429]=114; image[18430]=132; image[18431]=183; image[18432]=212; image[18433]=255; image[18434]=124; image[18435]=0; image[18436]=5; image[18437]=41; image[18438]=151; image[18439]=200; image[18440]=197; image[18441]=201; image[18442]=165; image[18443]=153; image[18444]=122; image[18445]=95; image[18446]=108; image[18447]=145; image[18448]=217; image[18449]=255; image[18450]=255; image[18451]=255; image[18452]=255; image[18453]=255; image[18454]=115; image[18455]=124; image[18456]=176; image[18457]=253; image[18458]=255; image[18459]=255; image[18460]=255; image[18461]=150; image[18462]=202; image[18463]=48; image[18464]=25; image[18465]=4; image[18466]=2; image[18467]=1; image[18468]=1; image[18469]=1; image[18470]=1; image[18471]=1; image[18472]=1; image[18473]=1; image[18474]=1; image[18475]=1; image[18476]=1; image[18477]=1; image[18478]=1; image[18479]=1; image[18480]=1; image[18481]=1; image[18482]=1; image[18483]=1; image[18484]=1; image[18485]=1; image[18486]=1; image[18487]=1; image[18488]=1; image[18489]=1; image[18490]=1; image[18491]=1; image[18492]=1; image[18493]=1; image[18494]=1; image[18495]=1; image[18496]=1; image[18497]=1; image[18498]=1; image[18499]=1; image[18500]=1; image[18501]=1; image[18502]=1; image[18503]=1; image[18504]=1; image[18505]=1; image[18506]=1; image[18507]=1; image[18508]=1; image[18509]=1; image[18510]=1; image[18511]=1; image[18512]=1; image[18513]=1; image[18514]=1; image[18515]=1; image[18516]=1; image[18517]=1; image[18518]=1; image[18519]=1; image[18520]=1; image[18521]=1; image[18522]=1; image[18523]=1; image[18524]=1; image[18525]=1; image[18526]=1; image[18527]=1; image[18528]=1; image[18529]=1; image[18530]=1; image[18531]=1; image[18532]=1; image[18533]=1; image[18534]=1; image[18535]=1; image[18536]=2; image[18537]=1; image[18538]=1; image[18539]=1; image[18540]=1; image[18541]=1; image[18542]=1; image[18543]=1; image[18544]=1; image[18545]=1; image[18546]=1; image[18547]=1; image[18548]=1; image[18549]=1; image[18550]=1; image[18551]=1; image[18552]=1; image[18553]=1; image[18554]=1; image[18555]=1; image[18556]=1; image[18557]=1; image[18558]=1; image[18559]=1; image[18560]=1; image[18561]=1; image[18562]=1; image[18563]=2; image[18564]=1; image[18565]=1; image[18566]=1; image[18567]=1; image[18568]=1; image[18569]=2; image[18570]=2; image[18571]=2; image[18572]=3; image[18573]=3; image[18574]=5; image[18575]=4; image[18576]=5; image[18577]=7; image[18578]=6; image[18579]=3; image[18580]=1; image[18581]=1; image[18582]=1; image[18583]=1; image[18584]=2; image[18585]=3; image[18586]=5; image[18587]=5; image[18588]=6; image[18589]=8; image[18590]=7; image[18591]=10; image[18592]=14; image[18593]=10; image[18594]=6; image[18595]=3; image[18596]=4; image[18597]=6; image[18598]=4; image[18599]=4; image[18600]=4; image[18601]=9; image[18602]=16; image[18603]=21; image[18604]=29; image[18605]=35; image[18606]=35; image[18607]=38; image[18608]=48; image[18609]=51; image[18610]=52; image[18611]=53; image[18612]=57; image[18613]=54; image[18614]=43; image[18615]=27; image[18616]=17; image[18617]=9; image[18618]=6; image[18619]=14; image[18620]=25; image[18621]=36; image[18622]=37; image[18623]=35; image[18624]=41; image[18625]=81; image[18626]=80; image[18627]=113; image[18628]=92; image[18629]=133; image[18630]=180; image[18631]=216; image[18632]=255; image[18633]=130; image[18634]=4; image[18635]=8; image[18636]=23; image[18637]=62; image[18638]=150; image[18639]=167; image[18640]=169; image[18641]=159; image[18642]=148; image[18643]=140; image[18644]=141; image[18645]=146; image[18646]=131; image[18647]=204; image[18648]=255; image[18649]=255; image[18650]=255; image[18651]=255; image[18652]=241; image[18653]=87; image[18654]=118; image[18655]=187; image[18656]=235; image[18657]=255; image[18658]=255; image[18659]=255; image[18660]=160; image[18661]=238; image[18662]=55; image[18663]=32; image[18664]=4; image[18665]=2; image[18666]=1; image[18667]=1; image[18668]=1; image[18669]=1; image[18670]=1; image[18671]=1; image[18672]=1; image[18673]=1; image[18674]=1; image[18675]=1; image[18676]=1; image[18677]=1; image[18678]=1; image[18679]=1; image[18680]=1; image[18681]=1; image[18682]=1; image[18683]=1; image[18684]=1; image[18685]=1; image[18686]=2; image[18687]=1; image[18688]=1; image[18689]=1; image[18690]=1; image[18691]=1; image[18692]=1; image[18693]=1; image[18694]=1; image[18695]=1; image[18696]=1; image[18697]=1; image[18698]=1; image[18699]=1; image[18700]=1; image[18701]=1; image[18702]=1; image[18703]=1; image[18704]=1; image[18705]=1; image[18706]=1; image[18707]=1; image[18708]=1; image[18709]=1; image[18710]=1; image[18711]=1; image[18712]=1; image[18713]=1; image[18714]=1; image[18715]=1; image[18716]=1; image[18717]=1; image[18718]=1; image[18719]=1; image[18720]=1; image[18721]=1; image[18722]=1; image[18723]=1; image[18724]=1; image[18725]=1; image[18726]=1; image[18727]=1; image[18728]=1; image[18729]=1; image[18730]=1; image[18731]=1; image[18732]=1; image[18733]=1; image[18734]=1; image[18735]=1; image[18736]=1; image[18737]=1; image[18738]=1; image[18739]=1; image[18740]=1; image[18741]=1; image[18742]=1; image[18743]=1; image[18744]=1; image[18745]=1; image[18746]=1; image[18747]=1; image[18748]=1; image[18749]=1; image[18750]=1; image[18751]=1; image[18752]=1; image[18753]=1; image[18754]=1; image[18755]=1; image[18756]=1; image[18757]=1; image[18758]=1; image[18759]=1; image[18760]=1; image[18761]=1; image[18762]=2; image[18763]=1; image[18764]=1; image[18765]=1; image[18766]=1; image[18767]=1; image[18768]=2; image[18769]=1; image[18770]=2; image[18771]=2; image[18772]=2; image[18773]=2; image[18774]=3; image[18775]=3; image[18776]=5; image[18777]=5; image[18778]=3; image[18779]=2; image[18780]=2; image[18781]=1; image[18782]=2; image[18783]=3; image[18784]=3; image[18785]=4; image[18786]=5; image[18787]=6; image[18788]=7; image[18789]=7; image[18790]=10; image[18791]=13; image[18792]=11; image[18793]=6; image[18794]=4; image[18795]=4; image[18796]=5; image[18797]=6; image[18798]=10; image[18799]=10; image[18800]=13; image[18801]=25; image[18802]=34; image[18803]=34; image[18804]=36; image[18805]=35; image[18806]=39; image[18807]=48; image[18808]=47; image[18809]=48; image[18810]=50; image[18811]=57; image[18812]=53; image[18813]=40; image[18814]=24; image[18815]=11; image[18816]=6; image[18817]=6; image[18818]=12; image[18819]=26; image[18820]=36; image[18821]=35; image[18822]=33; image[18823]=37; image[18824]=80; image[18825]=76; image[18826]=115; image[18827]=100; image[18828]=137; image[18829]=193; image[18830]=241; image[18831]=255; image[18832]=128; image[18833]=5; image[18834]=9; image[18835]=55; image[18836]=94; image[18837]=116; image[18838]=154; image[18839]=171; image[18840]=149; image[18841]=143; image[18842]=154; image[18843]=141; image[18844]=129; image[18845]=119; image[18846]=187; image[18847]=232; image[18848]=246; image[18849]=255; image[18850]=255; image[18851]=194; image[18852]=76; image[18853]=123; image[18854]=154; image[18855]=189; image[18856]=255; image[18857]=255; image[18858]=255; image[18859]=192; image[18860]=227; image[18861]=40; image[18862]=30; image[18863]=4; image[18864]=1; image[18865]=1; image[18866]=1; image[18867]=1; image[18868]=1; image[18869]=1; image[18870]=1; image[18871]=1; image[18872]=1; image[18873]=1; image[18874]=1; image[18875]=1; image[18876]=1; image[18877]=1; image[18878]=1; image[18879]=1; image[18880]=1; image[18881]=1; image[18882]=1; image[18883]=1; image[18884]=1; image[18885]=1; image[18886]=1; image[18887]=1; image[18888]=1; image[18889]=1; image[18890]=1; image[18891]=1; image[18892]=1; image[18893]=1; image[18894]=1; image[18895]=1; image[18896]=1; image[18897]=1; image[18898]=1; image[18899]=1; image[18900]=1; image[18901]=1; image[18902]=1; image[18903]=1; image[18904]=1; image[18905]=1; image[18906]=1; image[18907]=1; image[18908]=1; image[18909]=1; image[18910]=1; image[18911]=1; image[18912]=1; image[18913]=1; image[18914]=1; image[18915]=1; image[18916]=1; image[18917]=1; image[18918]=1; image[18919]=1; image[18920]=1; image[18921]=1; image[18922]=1; image[18923]=1; image[18924]=1; image[18925]=1; image[18926]=1; image[18927]=1; image[18928]=1; image[18929]=1; image[18930]=1; image[18931]=1; image[18932]=1; image[18933]=1; image[18934]=1; image[18935]=1; image[18936]=1; image[18937]=1; image[18938]=1; image[18939]=1; image[18940]=1; image[18941]=1; image[18942]=1; image[18943]=1; image[18944]=1; image[18945]=1; image[18946]=1; image[18947]=1; image[18948]=1; image[18949]=1; image[18950]=1; image[18951]=1; image[18952]=1; image[18953]=1; image[18954]=1; image[18955]=1; image[18956]=1; image[18957]=1; image[18958]=1; image[18959]=1; image[18960]=1; image[18961]=1; image[18962]=1; image[18963]=1; image[18964]=1; image[18965]=1; image[18966]=1; image[18967]=1; image[18968]=1; image[18969]=2; image[18970]=1; image[18971]=1; image[18972]=1; image[18973]=2; image[18974]=2; image[18975]=2; image[18976]=3; image[18977]=4; image[18978]=4; image[18979]=3; image[18980]=2; image[18981]=4; image[18982]=5; image[18983]=5; image[18984]=5; image[18985]=6; image[18986]=7; image[18987]=7; image[18988]=7; image[18989]=8; image[18990]=12; image[18991]=15; image[18992]=7; image[18993]=4; image[18994]=4; image[18995]=4; image[18996]=5; image[18997]=10; image[18998]=11; image[18999]=12; image[19000]=25; image[19001]=38; image[19002]=32; image[19003]=32; image[19004]=38; image[19005]=41; image[19006]=48; image[19007]=48; image[19008]=43; image[19009]=47; image[19010]=46; image[19011]=29; image[19012]=14; image[19013]=9; image[19014]=10; image[19015]=16; image[19016]=13; image[19017]=9; image[19018]=29; image[19019]=36; image[19020]=39; image[19021]=36; image[19022]=30; image[19023]=73; image[19024]=76; image[19025]=126; image[19026]=102; image[19027]=144; image[19028]=211; image[19029]=240; image[19030]=255; image[19031]=144; image[19032]=9; image[19033]=10; image[19034]=75; image[19035]=120; image[19036]=79; image[19037]=133; image[19038]=175; image[19039]=160; image[19040]=168; image[19041]=158; image[19042]=128; image[19043]=112; image[19044]=104; image[19045]=146; image[19046]=154; image[19047]=201; image[19048]=247; image[19049]=255; image[19050]=137; image[19051]=72; image[19052]=117; image[19053]=118; image[19054]=134; image[19055]=252; image[19056]=255; image[19057]=255; image[19058]=225; image[19059]=219; image[19060]=41; image[19061]=28; image[19062]=4; image[19063]=1; image[19064]=1; image[19065]=1; image[19066]=1; image[19067]=1; image[19068]=1; image[19069]=1; image[19070]=1; image[19071]=1; image[19072]=1; image[19073]=1; image[19074]=1; image[19075]=1; image[19076]=1; image[19077]=1; image[19078]=1; image[19079]=1; image[19080]=1; image[19081]=1; image[19082]=1; image[19083]=1; image[19084]=1; image[19085]=1; image[19086]=1; image[19087]=1; image[19088]=1; image[19089]=1; image[19090]=1; image[19091]=1; image[19092]=1; image[19093]=1; image[19094]=1; image[19095]=1; image[19096]=1; image[19097]=1; image[19098]=1; image[19099]=1; image[19100]=1; image[19101]=1; image[19102]=1; image[19103]=1; image[19104]=1; image[19105]=1; image[19106]=1; image[19107]=1; image[19108]=1; image[19109]=1; image[19110]=1; image[19111]=1; image[19112]=1; image[19113]=1; image[19114]=1; image[19115]=1; image[19116]=1; image[19117]=1; image[19118]=1; image[19119]=1; image[19120]=1; image[19121]=1; image[19122]=1; image[19123]=1; image[19124]=1; image[19125]=1; image[19126]=1; image[19127]=1; image[19128]=1; image[19129]=1; image[19130]=1; image[19131]=1; image[19132]=1; image[19133]=1; image[19134]=1; image[19135]=1; image[19136]=1; image[19137]=1; image[19138]=1; image[19139]=1; image[19140]=1; image[19141]=1; image[19142]=1; image[19143]=1; image[19144]=1; image[19145]=1; image[19146]=1; image[19147]=1; image[19148]=1; image[19149]=1; image[19150]=1; image[19151]=1; image[19152]=1; image[19153]=1; image[19154]=1; image[19155]=1; image[19156]=1; image[19157]=1; image[19158]=1; image[19159]=1; image[19160]=1; image[19161]=1; image[19162]=1; image[19163]=2; image[19164]=1; image[19165]=1; image[19166]=1; image[19167]=1; image[19168]=1; image[19169]=1; image[19170]=1; image[19171]=1; image[19172]=1; image[19173]=1; image[19174]=2; image[19175]=3; image[19176]=3; image[19177]=5; image[19178]=5; image[19179]=5; image[19180]=5; image[19181]=5; image[19182]=5; image[19183]=6; image[19184]=7; image[19185]=6; image[19186]=7; image[19187]=8; image[19188]=7; image[19189]=9; image[19190]=16; image[19191]=9; image[19192]=8; image[19193]=13; image[19194]=13; image[19195]=7; image[19196]=5; image[19197]=5; image[19198]=5; image[19199]=7; image[19200]=11; image[19201]=18; image[19202]=20; image[19203]=16; image[19204]=15; image[19205]=16; image[19206]=19; image[19207]=18; image[19208]=17; image[19209]=22; image[19210]=24; image[19211]=28; image[19212]=33; image[19213]=31; image[19214]=32; image[19215]=24; image[19216]=6; image[19217]=19; image[19218]=33; image[19219]=35; image[19220]=32; image[19221]=29; image[19222]=74; image[19223]=78; image[19224]=136; image[19225]=114; image[19226]=146; image[19227]=200; image[19228]=197; image[19229]=235; image[19230]=121; image[19231]=13; image[19232]=12; image[19233]=159; image[19234]=200; image[19235]=55; image[19236]=76; image[19237]=141; image[19238]=153; image[19239]=165; image[19240]=165; image[19241]=147; image[19242]=118; image[19243]=103; image[19244]=129; image[19245]=128; image[19246]=208; image[19247]=241; image[19248]=156; image[19249]=76; image[19250]=77; image[19251]=121; image[19252]=139; image[19253]=121; image[19254]=233; image[19255]=255; image[19256]=254; image[19257]=192; image[19258]=142; image[19259]=46; image[19260]=35; image[19261]=4; image[19262]=2; image[19263]=1; image[19264]=1; image[19265]=1; image[19266]=1; image[19267]=1; image[19268]=1; image[19269]=1; image[19270]=1; image[19271]=1; image[19272]=1; image[19273]=1; image[19274]=1; image[19275]=1; image[19276]=1; image[19277]=1; image[19278]=1; image[19279]=1; image[19280]=1; image[19281]=1; image[19282]=1; image[19283]=1; image[19284]=1; image[19285]=1; image[19286]=1; image[19287]=1; image[19288]=1; image[19289]=1; image[19290]=1; image[19291]=1; image[19292]=1; image[19293]=1; image[19294]=1; image[19295]=1; image[19296]=1; image[19297]=1; image[19298]=1; image[19299]=1; image[19300]=1; image[19301]=1; image[19302]=1; image[19303]=1; image[19304]=1; image[19305]=1; image[19306]=1; image[19307]=1; image[19308]=1; image[19309]=1; image[19310]=1; image[19311]=1; image[19312]=1; image[19313]=1; image[19314]=1; image[19315]=1; image[19316]=1; image[19317]=1; image[19318]=1; image[19319]=1; image[19320]=1; image[19321]=1; image[19322]=1; image[19323]=1; image[19324]=1; image[19325]=1; image[19326]=1; image[19327]=1; image[19328]=1; image[19329]=1; image[19330]=1; image[19331]=1; image[19332]=1; image[19333]=1; image[19334]=1; image[19335]=1; image[19336]=1; image[19337]=1; image[19338]=1; image[19339]=1; image[19340]=1; image[19341]=1; image[19342]=1; image[19343]=1; image[19344]=1; image[19345]=1; image[19346]=1; image[19347]=1; image[19348]=1; image[19349]=1; image[19350]=1; image[19351]=1; image[19352]=1; image[19353]=1; image[19354]=1; image[19355]=1; image[19356]=1; image[19357]=1; image[19358]=1; image[19359]=1; image[19360]=1; image[19361]=1; image[19362]=1; image[19363]=1; image[19364]=1; image[19365]=1; image[19366]=1; image[19367]=1; image[19368]=1; image[19369]=1; image[19370]=1; image[19371]=1; image[19372]=1; image[19373]=1; image[19374]=1; image[19375]=3; image[19376]=4; image[19377]=6; image[19378]=8; image[19379]=7; image[19380]=7; image[19381]=6; image[19382]=7; image[19383]=7; image[19384]=6; image[19385]=6; image[19386]=7; image[19387]=7; image[19388]=9; image[19389]=13; image[19390]=9; image[19391]=10; image[19392]=18; image[19393]=17; image[19394]=10; image[19395]=12; image[19396]=11; image[19397]=9; image[19398]=7; image[19399]=8; image[19400]=11; image[19401]=13; image[19402]=10; image[19403]=10; image[19404]=12; image[19405]=17; image[19406]=16; image[19407]=17; image[19408]=24; image[19409]=25; image[19410]=29; image[19411]=35; image[19412]=35; image[19413]=33; image[19414]=29; image[19415]=8; image[19416]=18; image[19417]=30; image[19418]=31; image[19419]=33; image[19420]=29; image[19421]=74; image[19422]=80; image[19423]=139; image[19424]=122; image[19425]=149; image[19426]=203; image[19427]=190; image[19428]=184; image[19429]=104; image[19430]=19; image[19431]=12; image[19432]=180; image[19433]=247; image[19434]=103; image[19435]=46; image[19436]=89; image[19437]=122; image[19438]=159; image[19439]=176; image[19440]=128; image[19441]=105; image[19442]=109; image[19443]=125; image[19444]=126; image[19445]=194; image[19446]=212; image[19447]=112; image[19448]=54; image[19449]=78; image[19450]=129; image[19451]=153; image[19452]=120; image[19453]=227; image[19454]=255; image[19455]=249; image[19456]=221; image[19457]=193; image[19458]=41; image[19459]=35; image[19460]=4; image[19461]=2; image[19462]=1; image[19463]=1; image[19464]=1; image[19465]=1; image[19466]=1; image[19467]=1; image[19468]=1; image[19469]=1; image[19470]=1; image[19471]=1; image[19472]=1; image[19473]=1; image[19474]=1; image[19475]=1; image[19476]=1; image[19477]=1; image[19478]=1; image[19479]=1; image[19480]=1; image[19481]=1; image[19482]=1; image[19483]=1; image[19484]=1; image[19485]=1; image[19486]=1; image[19487]=1; image[19488]=1; image[19489]=1; image[19490]=1; image[19491]=1; image[19492]=1; image[19493]=1; image[19494]=1; image[19495]=1; image[19496]=1; image[19497]=1; image[19498]=1; image[19499]=1; image[19500]=1; image[19501]=1; image[19502]=1; image[19503]=1; image[19504]=1; image[19505]=1; image[19506]=1; image[19507]=1; image[19508]=1; image[19509]=1; image[19510]=1; image[19511]=1; image[19512]=1; image[19513]=1; image[19514]=1; image[19515]=1; image[19516]=1; image[19517]=1; image[19518]=1; image[19519]=1; image[19520]=1; image[19521]=1; image[19522]=1; image[19523]=1; image[19524]=1; image[19525]=1; image[19526]=1; image[19527]=1; image[19528]=1; image[19529]=1; image[19530]=1; image[19531]=1; image[19532]=1; image[19533]=1; image[19534]=1; image[19535]=1; image[19536]=1; image[19537]=1; image[19538]=1; image[19539]=1; image[19540]=1; image[19541]=1; image[19542]=1; image[19543]=1; image[19544]=1; image[19545]=1; image[19546]=1; image[19547]=1; image[19548]=1; image[19549]=1; image[19550]=1; image[19551]=1; image[19552]=1; image[19553]=1; image[19554]=1; image[19555]=1; image[19556]=1; image[19557]=1; image[19558]=1; image[19559]=1; image[19560]=1; image[19561]=1; image[19562]=2; image[19563]=1; image[19564]=1; image[19565]=1; image[19566]=1; image[19567]=1; image[19568]=1; image[19569]=1; image[19570]=1; image[19571]=1; image[19572]=1; image[19573]=1; image[19574]=1; image[19575]=3; image[19576]=6; image[19577]=9; image[19578]=9; image[19579]=9; image[19580]=10; image[19581]=8; image[19582]=8; image[19583]=6; image[19584]=7; image[19585]=7; image[19586]=8; image[19587]=10; image[19588]=13; image[19589]=12; image[19590]=14; image[19591]=16; image[19592]=14; image[19593]=10; image[19594]=15; image[19595]=13; image[19596]=14; image[19597]=12; image[19598]=13; image[19599]=13; image[19600]=14; image[19601]=15; image[19602]=17; image[19603]=17; image[19604]=22; image[19605]=18; image[19606]=19; image[19607]=22; image[19608]=29; image[19609]=39; image[19610]=38; image[19611]=40; image[19612]=37; image[19613]=33; image[19614]=11; image[19615]=22; image[19616]=33; image[19617]=33; image[19618]=35; image[19619]=28; image[19620]=77; image[19621]=84; image[19622]=140; image[19623]=131; image[19624]=132; image[19625]=187; image[19626]=155; image[19627]=96; image[19628]=49; image[19629]=10; image[19630]=7; image[19631]=89; image[19632]=255; image[19633]=217; image[19634]=103; image[19635]=59; image[19636]=93; image[19637]=153; image[19638]=156; image[19639]=123; image[19640]=104; image[19641]=102; image[19642]=116; image[19643]=122; image[19644]=153; image[19645]=172; image[19646]=88; image[19647]=40; image[19648]=78; image[19649]=122; image[19650]=145; image[19651]=123; image[19652]=227; image[19653]=255; image[19654]=255; image[19655]=255; image[19656]=237; image[19657]=60; image[19658]=35; image[19659]=4; image[19660]=2; image[19661]=1; image[19662]=1; image[19663]=1; image[19664]=1; image[19665]=1; image[19666]=1; image[19667]=1; image[19668]=1; image[19669]=1; image[19670]=1; image[19671]=1; image[19672]=1; image[19673]=1; image[19674]=1; image[19675]=1; image[19676]=1; image[19677]=1; image[19678]=1; image[19679]=1; image[19680]=1; image[19681]=1; image[19682]=1; image[19683]=1; image[19684]=1; image[19685]=1; image[19686]=1; image[19687]=1; image[19688]=1; image[19689]=1; image[19690]=1; image[19691]=1; image[19692]=1; image[19693]=1; image[19694]=1; image[19695]=1; image[19696]=1; image[19697]=1; image[19698]=2; image[19699]=1; image[19700]=1; image[19701]=1; image[19702]=1; image[19703]=1; image[19704]=1; image[19705]=1; image[19706]=1; image[19707]=1; image[19708]=1; image[19709]=1; image[19710]=1; image[19711]=1; image[19712]=1; image[19713]=1; image[19714]=1; image[19715]=1; image[19716]=1; image[19717]=1; image[19718]=1; image[19719]=1; image[19720]=1; image[19721]=1; image[19722]=1; image[19723]=1; image[19724]=1; image[19725]=1; image[19726]=1; image[19727]=1; image[19728]=1; image[19729]=1; image[19730]=1; image[19731]=1; image[19732]=1; image[19733]=1; image[19734]=1; image[19735]=1; image[19736]=1; image[19737]=1; image[19738]=1; image[19739]=1; image[19740]=1; image[19741]=1; image[19742]=1; image[19743]=1; image[19744]=1; image[19745]=1; image[19746]=1; image[19747]=1; image[19748]=1; image[19749]=1; image[19750]=1; image[19751]=1; image[19752]=1; image[19753]=1; image[19754]=1; image[19755]=1; image[19756]=1; image[19757]=1; image[19758]=1; image[19759]=1; image[19760]=1; image[19761]=1; image[19762]=1; image[19763]=1; image[19764]=1; image[19765]=1; image[19766]=1; image[19767]=1; image[19768]=1; image[19769]=1; image[19770]=1; image[19771]=1; image[19772]=1; image[19773]=1; image[19774]=2; image[19775]=4; image[19776]=8; image[19777]=9; image[19778]=11; image[19779]=12; image[19780]=8; image[19781]=6; image[19782]=6; image[19783]=7; image[19784]=7; image[19785]=8; image[19786]=10; image[19787]=12; image[19788]=12; image[19789]=15; image[19790]=14; image[19791]=8; image[19792]=5; image[19793]=12; image[19794]=12; image[19795]=11; image[19796]=12; image[19797]=15; image[19798]=15; image[19799]=15; image[19800]=17; image[19801]=20; image[19802]=25; image[19803]=29; image[19804]=33; image[19805]=37; image[19806]=40; image[19807]=40; image[19808]=42; image[19809]=46; image[19810]=49; image[19811]=42; image[19812]=31; image[19813]=10; image[19814]=22; image[19815]=33; image[19816]=34; image[19817]=38; image[19818]=30; image[19819]=80; image[19820]=78; image[19821]=128; image[19822]=138; image[19823]=127; image[19824]=180; image[19825]=152; image[19826]=75; image[19827]=15; image[19828]=4; image[19829]=5; image[19830]=30; image[19831]=182; image[19832]=239; image[19833]=166; image[19834]=104; image[19835]=100; image[19836]=129; image[19837]=155; image[19838]=160; image[19839]=139; image[19840]=116; image[19841]=127; image[19842]=124; image[19843]=156; image[19844]=166; image[19845]=80; image[19846]=37; image[19847]=76; image[19848]=133; image[19849]=156; image[19850]=134; image[19851]=239; image[19852]=255; image[19853]=242; image[19854]=221; image[19855]=232; image[19856]=44; image[19857]=31; image[19858]=4; image[19859]=2; image[19860]=1; image[19861]=1; image[19862]=1; image[19863]=1; image[19864]=1; image[19865]=1; image[19866]=1; image[19867]=1; image[19868]=1; image[19869]=1; image[19870]=1; image[19871]=1; image[19872]=1; image[19873]=1; image[19874]=1; image[19875]=1; image[19876]=1; image[19877]=1; image[19878]=1; image[19879]=1; image[19880]=1; image[19881]=1; image[19882]=1; image[19883]=1; image[19884]=1; image[19885]=1; image[19886]=1; image[19887]=1; image[19888]=1; image[19889]=1; image[19890]=1; image[19891]=1; image[19892]=1; image[19893]=1; image[19894]=1; image[19895]=1; image[19896]=1; image[19897]=1; image[19898]=1; image[19899]=1; image[19900]=1; image[19901]=1; image[19902]=1; image[19903]=1; image[19904]=1; image[19905]=1; image[19906]=1; image[19907]=1; image[19908]=1; image[19909]=1; image[19910]=1; image[19911]=1; image[19912]=1; image[19913]=1; image[19914]=1; image[19915]=1; image[19916]=1; image[19917]=1; image[19918]=1; image[19919]=1; image[19920]=1; image[19921]=1; image[19922]=1; image[19923]=1; image[19924]=1; image[19925]=1; image[19926]=1; image[19927]=1; image[19928]=1; image[19929]=1; image[19930]=1; image[19931]=1; image[19932]=1; image[19933]=1; image[19934]=1; image[19935]=1; image[19936]=1; image[19937]=1; image[19938]=1; image[19939]=1; image[19940]=1; image[19941]=1; image[19942]=1; image[19943]=1; image[19944]=1; image[19945]=1; image[19946]=1; image[19947]=1; image[19948]=1; image[19949]=1; image[19950]=1; image[19951]=1; image[19952]=1; image[19953]=1; image[19954]=1; image[19955]=1; image[19956]=1; image[19957]=1; image[19958]=1; image[19959]=1; image[19960]=1; image[19961]=1; image[19962]=1; image[19963]=1; image[19964]=1; image[19965]=1; image[19966]=1; image[19967]=1; image[19968]=1; image[19969]=1; image[19970]=1; image[19971]=1; image[19972]=1; image[19973]=2; image[19974]=3; image[19975]=6; image[19976]=9; image[19977]=11; image[19978]=11; image[19979]=9; image[19980]=7; image[19981]=6; image[19982]=7; image[19983]=7; image[19984]=8; image[19985]=9; image[19986]=12; image[19987]=12; image[19988]=13; image[19989]=9; image[19990]=4; image[19991]=2; image[19992]=8; image[19993]=10; image[19994]=11; image[19995]=14; image[19996]=16; image[19997]=21; image[19998]=21; image[19999]=21; image[20000]=24; image[20001]=37; image[20002]=41; image[20003]=41; image[20004]=46; image[20005]=53; image[20006]=51; image[20007]=49; image[20008]=44; image[20009]=50; image[20010]=46; image[20011]=23; image[20012]=9; image[20013]=26; image[20014]=35; image[20015]=35; image[20016]=40; image[20017]=31; image[20018]=85; image[20019]=77; image[20020]=124; image[20021]=145; image[20022]=125; image[20023]=179; image[20024]=167; image[20025]=89; image[20026]=8; image[20027]=4; image[20028]=4; image[20029]=12; image[20030]=92; image[20031]=239; image[20032]=235; image[20033]=179; image[20034]=116; image[20035]=108; image[20036]=146; image[20037]=149; image[20038]=130; image[20039]=117; image[20040]=128; image[20041]=143; image[20042]=165; image[20043]=148; image[20044]=78; image[20045]=42; image[20046]=69; image[20047]=134; image[20048]=161; image[20049]=144; image[20050]=251; image[20051]=255; image[20052]=208; image[20053]=208; image[20054]=231; image[20055]=37; image[20056]=28; image[20057]=4; image[20058]=2; image[20059]=1; image[20060]=1; image[20061]=1; image[20062]=1; image[20063]=1; image[20064]=1; image[20065]=1; image[20066]=1; image[20067]=1; image[20068]=1; image[20069]=1; image[20070]=1; image[20071]=1; image[20072]=1; image[20073]=1; image[20074]=1; image[20075]=1; image[20076]=1; image[20077]=1; image[20078]=1; image[20079]=1; image[20080]=1; image[20081]=1; image[20082]=1; image[20083]=1; image[20084]=1; image[20085]=1; image[20086]=1; image[20087]=1; image[20088]=1; image[20089]=1; image[20090]=1; image[20091]=1; image[20092]=1; image[20093]=1; image[20094]=1; image[20095]=1; image[20096]=1; image[20097]=1; image[20098]=1; image[20099]=1; image[20100]=1; image[20101]=1; image[20102]=1; image[20103]=1; image[20104]=1; image[20105]=1; image[20106]=1; image[20107]=1; image[20108]=1; image[20109]=1; image[20110]=1; image[20111]=1; image[20112]=1; image[20113]=1; image[20114]=1; image[20115]=1; image[20116]=1; image[20117]=1; image[20118]=1; image[20119]=1; image[20120]=1; image[20121]=1; image[20122]=1; image[20123]=1; image[20124]=1; image[20125]=1; image[20126]=1; image[20127]=1; image[20128]=1; image[20129]=1; image[20130]=1; image[20131]=1; image[20132]=1; image[20133]=1; image[20134]=1; image[20135]=1; image[20136]=1; image[20137]=1; image[20138]=1; image[20139]=1; image[20140]=1; image[20141]=1; image[20142]=1; image[20143]=1; image[20144]=1; image[20145]=1; image[20146]=1; image[20147]=1; image[20148]=1; image[20149]=1; image[20150]=1; image[20151]=1; image[20152]=1; image[20153]=1; image[20154]=1; image[20155]=1; image[20156]=1; image[20157]=1; image[20158]=1; image[20159]=1; image[20160]=1; image[20161]=1; image[20162]=1; image[20163]=1; image[20164]=1; image[20165]=1; image[20166]=1; image[20167]=1; image[20168]=1; image[20169]=1; image[20170]=1; image[20171]=1; image[20172]=1; image[20173]=2; image[20174]=5; image[20175]=10; image[20176]=13; image[20177]=12; image[20178]=11; image[20179]=9; image[20180]=6; image[20181]=7; image[20182]=6; image[20183]=7; image[20184]=9; image[20185]=16; image[20186]=14; image[20187]=16; image[20188]=16; image[20189]=8; image[20190]=4; image[20191]=4; image[20192]=7; image[20193]=18; image[20194]=23; image[20195]=31; image[20196]=36; image[20197]=28; image[20198]=30; image[20199]=38; image[20200]=40; image[20201]=46; image[20202]=42; image[20203]=40; image[20204]=53; image[20205]=62; image[20206]=58; image[20207]=51; image[20208]=61; image[20209]=42; image[20210]=24; image[20211]=12; image[20212]=33; image[20213]=37; image[20214]=41; image[20215]=42; image[20216]=35; image[20217]=80; image[20218]=78; image[20219]=115; image[20220]=169; image[20221]=140; image[20222]=204; image[20223]=216; image[20224]=100; image[20225]=10; image[20226]=49; image[20227]=65; image[20228]=33; image[20229]=35; image[20230]=140; image[20231]=235; image[20232]=255; image[20233]=243; image[20234]=166; image[20235]=150; image[20236]=133; image[20237]=119; image[20238]=133; image[20239]=155; image[20240]=186; image[20241]=187; image[20242]=151; image[20243]=98; image[20244]=49; image[20245]=74; image[20246]=156; image[20247]=163; image[20248]=142; image[20249]=255; image[20250]=255; image[20251]=197; image[20252]=213; image[20253]=230; image[20254]=44; image[20255]=37; image[20256]=4; image[20257]=2; image[20258]=1; image[20259]=1; image[20260]=1; image[20261]=1; image[20262]=1; image[20263]=1; image[20264]=1; image[20265]=1; image[20266]=1; image[20267]=1; image[20268]=1; image[20269]=1; image[20270]=1; image[20271]=1; image[20272]=1; image[20273]=1; image[20274]=1; image[20275]=1; image[20276]=1; image[20277]=1; image[20278]=1; image[20279]=1; image[20280]=1; image[20281]=1; image[20282]=1; image[20283]=1; image[20284]=1; image[20285]=1; image[20286]=1; image[20287]=1; image[20288]=1; image[20289]=1; image[20290]=1; image[20291]=1; image[20292]=1; image[20293]=1; image[20294]=1; image[20295]=1; image[20296]=1; image[20297]=1; image[20298]=1; image[20299]=1; image[20300]=1; image[20301]=1; image[20302]=1; image[20303]=1; image[20304]=1; image[20305]=1; image[20306]=1; image[20307]=1; image[20308]=1; image[20309]=1; image[20310]=1; image[20311]=1; image[20312]=1; image[20313]=1; image[20314]=1; image[20315]=1; image[20316]=1; image[20317]=1; image[20318]=1; image[20319]=1; image[20320]=1; image[20321]=1; image[20322]=1; image[20323]=1; image[20324]=1; image[20325]=1; image[20326]=1; image[20327]=1; image[20328]=1; image[20329]=1; image[20330]=1; image[20331]=1; image[20332]=1; image[20333]=1; image[20334]=1; image[20335]=1; image[20336]=1; image[20337]=1; image[20338]=1; image[20339]=1; image[20340]=1; image[20341]=1; image[20342]=1; image[20343]=1; image[20344]=1; image[20345]=1; image[20346]=1; image[20347]=1; image[20348]=1; image[20349]=1; image[20350]=1; image[20351]=1; image[20352]=1; image[20353]=1; image[20354]=1; image[20355]=1; image[20356]=1; image[20357]=1; image[20358]=1; image[20359]=1; image[20360]=1; image[20361]=1; image[20362]=1; image[20363]=1; image[20364]=1; image[20365]=1; image[20366]=1; image[20367]=1; image[20368]=1; image[20369]=1; image[20370]=1; image[20371]=1; image[20372]=1; image[20373]=3; image[20374]=9; image[20375]=12; image[20376]=12; image[20377]=11; image[20378]=9; image[20379]=6; image[20380]=7; image[20381]=6; image[20382]=7; image[20383]=9; image[20384]=19; image[20385]=16; image[20386]=19; image[20387]=27; image[20388]=14; image[20389]=6; image[20390]=5; image[20391]=10; image[20392]=21; image[20393]=24; image[20394]=29; image[20395]=36; image[20396]=32; image[20397]=33; image[20398]=38; image[20399]=37; image[20400]=38; image[20401]=37; image[20402]=41; image[20403]=55; image[20404]=56; image[20405]=49; image[20406]=48; image[20407]=63; image[20408]=42; image[20409]=32; image[20410]=19; image[20411]=35; image[20412]=35; image[20413]=39; image[20414]=37; image[20415]=34; image[20416]=83; image[20417]=91; image[20418]=110; image[20419]=174; image[20420]=143; image[20421]=195; image[20422]=227; image[20423]=122; image[20424]=26; image[20425]=88; image[20426]=106; image[20427]=69; image[20428]=33; image[20429]=72; image[20430]=140; image[20431]=214; image[20432]=248; image[20433]=235; image[20434]=197; image[20435]=135; image[20436]=113; image[20437]=130; image[20438]=154; image[20439]=191; image[20440]=202; image[20441]=158; image[20442]=103; image[20443]=53; image[20444]=79; image[20445]=145; image[20446]=166; image[20447]=183; image[20448]=255; image[20449]=255; image[20450]=192; image[20451]=201; image[20452]=230; image[20453]=32; image[20454]=28; image[20455]=4; image[20456]=1; image[20457]=1; image[20458]=1; image[20459]=1; image[20460]=1; image[20461]=1; image[20462]=1; image[20463]=1; image[20464]=1; image[20465]=1; image[20466]=1; image[20467]=1; image[20468]=1; image[20469]=1; image[20470]=1; image[20471]=1; image[20472]=1; image[20473]=1; image[20474]=1; image[20475]=1; image[20476]=1; image[20477]=1; image[20478]=1; image[20479]=1; image[20480]=1; image[20481]=1; image[20482]=1; image[20483]=1; image[20484]=1; image[20485]=1; image[20486]=1; image[20487]=1; image[20488]=1; image[20489]=1; image[20490]=1; image[20491]=1; image[20492]=1; image[20493]=1; image[20494]=1; image[20495]=1; image[20496]=1; image[20497]=1; image[20498]=1; image[20499]=1; image[20500]=1; image[20501]=1; image[20502]=1; image[20503]=1; image[20504]=1; image[20505]=1; image[20506]=1; image[20507]=1; image[20508]=1; image[20509]=1; image[20510]=1; image[20511]=1; image[20512]=1; image[20513]=1; image[20514]=1; image[20515]=1; image[20516]=1; image[20517]=1; image[20518]=1; image[20519]=1; image[20520]=1; image[20521]=1; image[20522]=1; image[20523]=1; image[20524]=1; image[20525]=1; image[20526]=1; image[20527]=1; image[20528]=1; image[20529]=1; image[20530]=1; image[20531]=1; image[20532]=1; image[20533]=1; image[20534]=1; image[20535]=1; image[20536]=1; image[20537]=1; image[20538]=1; image[20539]=1; image[20540]=1; image[20541]=1; image[20542]=1; image[20543]=1; image[20544]=1; image[20545]=1; image[20546]=1; image[20547]=1; image[20548]=1; image[20549]=1; image[20550]=1; image[20551]=1; image[20552]=1; image[20553]=1; image[20554]=1; image[20555]=1; image[20556]=1; image[20557]=1; image[20558]=1; image[20559]=1; image[20560]=1; image[20561]=1; image[20562]=1; image[20563]=1; image[20564]=1; image[20565]=1; image[20566]=1; image[20567]=1; image[20568]=1; image[20569]=1; image[20570]=1; image[20571]=1; image[20572]=2; image[20573]=7; image[20574]=11; image[20575]=11; image[20576]=12; image[20577]=11; image[20578]=7; image[20579]=8; image[20580]=7; image[20581]=7; image[20582]=10; image[20583]=23; image[20584]=22; image[20585]=16; image[20586]=24; image[20587]=17; image[20588]=6; image[20589]=6; image[20590]=12; image[20591]=25; image[20592]=26; image[20593]=28; image[20594]=34; image[20595]=31; image[20596]=32; image[20597]=34; image[20598]=38; image[20599]=37; image[20600]=37; image[20601]=40; image[20602]=52; image[20603]=55; image[20604]=56; image[20605]=53; image[20606]=59; image[20607]=41; image[20608]=33; image[20609]=20; image[20610]=36; image[20611]=34; image[20612]=38; image[20613]=37; image[20614]=32; image[20615]=85; image[20616]=95; image[20617]=104; image[20618]=186; image[20619]=146; image[20620]=195; image[20621]=235; image[20622]=125; image[20623]=27; image[20624]=85; image[20625]=89; image[20626]=99; image[20627]=55; image[20628]=55; image[20629]=85; image[20630]=90; image[20631]=179; image[20632]=255; image[20633]=244; image[20634]=152; image[20635]=101; image[20636]=109; image[20637]=140; image[20638]=192; image[20639]=209; image[20640]=152; image[20641]=102; image[20642]=60; image[20643]=101; image[20644]=146; image[20645]=160; image[20646]=227; image[20647]=255; image[20648]=255; image[20649]=205; image[20650]=220; image[20651]=235; image[20652]=36; image[20653]=20; image[20654]=4; image[20655]=1; image[20656]=1; image[20657]=1; image[20658]=1; image[20659]=1; image[20660]=1; image[20661]=1; image[20662]=1; image[20663]=1; image[20664]=1; image[20665]=1; image[20666]=1; image[20667]=1; image[20668]=1; image[20669]=1; image[20670]=1; image[20671]=1; image[20672]=1; image[20673]=1; image[20674]=1; image[20675]=1; image[20676]=1; image[20677]=1; image[20678]=1; image[20679]=1; image[20680]=1; image[20681]=1; image[20682]=1; image[20683]=1; image[20684]=1; image[20685]=1; image[20686]=1; image[20687]=1; image[20688]=1; image[20689]=1; image[20690]=1; image[20691]=1; image[20692]=1; image[20693]=1; image[20694]=1; image[20695]=1; image[20696]=1; image[20697]=1; image[20698]=1; image[20699]=1; image[20700]=1; image[20701]=1; image[20702]=1; image[20703]=1; image[20704]=1; image[20705]=1; image[20706]=1; image[20707]=1; image[20708]=1; image[20709]=1; image[20710]=1; image[20711]=1; image[20712]=1; image[20713]=1; image[20714]=1; image[20715]=1; image[20716]=1; image[20717]=1; image[20718]=1; image[20719]=1; image[20720]=1; image[20721]=1; image[20722]=1; image[20723]=1; image[20724]=1; image[20725]=1; image[20726]=1; image[20727]=1; image[20728]=1; image[20729]=1; image[20730]=1; image[20731]=1; image[20732]=1; image[20733]=1; image[20734]=1; image[20735]=1; image[20736]=1; image[20737]=1; image[20738]=1; image[20739]=1; image[20740]=1; image[20741]=1; image[20742]=1; image[20743]=1; image[20744]=1; image[20745]=1; image[20746]=1; image[20747]=1; image[20748]=1; image[20749]=1; image[20750]=1; image[20751]=1; image[20752]=1; image[20753]=1; image[20754]=1; image[20755]=1; image[20756]=1; image[20757]=1; image[20758]=1; image[20759]=1; image[20760]=1; image[20761]=1; image[20762]=1; image[20763]=1; image[20764]=1; image[20765]=1; image[20766]=1; image[20767]=1; image[20768]=1; image[20769]=1; image[20770]=2; image[20771]=3; image[20772]=7; image[20773]=12; image[20774]=14; image[20775]=11; image[20776]=9; image[20777]=6; image[20778]=8; image[20779]=9; image[20780]=8; image[20781]=11; image[20782]=21; image[20783]=23; image[20784]=21; image[20785]=18; image[20786]=15; image[20787]=6; image[20788]=5; image[20789]=11; image[20790]=20; image[20791]=22; image[20792]=26; image[20793]=32; image[20794]=29; image[20795]=30; image[20796]=34; image[20797]=38; image[20798]=37; image[20799]=38; image[20800]=43; image[20801]=47; image[20802]=49; image[20803]=48; image[20804]=53; image[20805]=45; image[20806]=41; image[20807]=31; image[20808]=17; image[20809]=35; image[20810]=37; image[20811]=36; image[20812]=38; image[20813]=31; image[20814]=75; image[20815]=87; image[20816]=89; image[20817]=198; image[20818]=163; image[20819]=191; image[20820]=207; image[20821]=180; image[20822]=44; image[20823]=71; image[20824]=118; image[20825]=112; image[20826]=89; image[20827]=64; image[20828]=88; image[20829]=114; image[20830]=156; image[20831]=237; image[20832]=254; image[20833]=244; image[20834]=155; image[20835]=94; image[20836]=156; image[20837]=203; image[20838]=180; image[20839]=140; image[20840]=95; image[20841]=76; image[20842]=131; image[20843]=179; image[20844]=170; image[20845]=239; image[20846]=255; image[20847]=255; image[20848]=201; image[20849]=206; image[20850]=174; image[20851]=29; image[20852]=26; image[20853]=4; image[20854]=2; image[20855]=1; image[20856]=1; image[20857]=1; image[20858]=1; image[20859]=1; image[20860]=1; image[20861]=1; image[20862]=1; image[20863]=1; image[20864]=1; image[20865]=1; image[20866]=1; image[20867]=1; image[20868]=1; image[20869]=1; image[20870]=1; image[20871]=1; image[20872]=1; image[20873]=1; image[20874]=1; image[20875]=1; image[20876]=1; image[20877]=1; image[20878]=1; image[20879]=1; image[20880]=1; image[20881]=1; image[20882]=1; image[20883]=1; image[20884]=1; image[20885]=1; image[20886]=1; image[20887]=1; image[20888]=1; image[20889]=1; image[20890]=1; image[20891]=1; image[20892]=1; image[20893]=1; image[20894]=1; image[20895]=1; image[20896]=1; image[20897]=1; image[20898]=1; image[20899]=1; image[20900]=1; image[20901]=1; image[20902]=1; image[20903]=1; image[20904]=1; image[20905]=1; image[20906]=1; image[20907]=1; image[20908]=1; image[20909]=1; image[20910]=1; image[20911]=1; image[20912]=1; image[20913]=1; image[20914]=1; image[20915]=1; image[20916]=1; image[20917]=1; image[20918]=1; image[20919]=1; image[20920]=1; image[20921]=1; image[20922]=1; image[20923]=1; image[20924]=1; image[20925]=1; image[20926]=1; image[20927]=1; image[20928]=1; image[20929]=1; image[20930]=1; image[20931]=1; image[20932]=1; image[20933]=1; image[20934]=1; image[20935]=1; image[20936]=1; image[20937]=1; image[20938]=1; image[20939]=1; image[20940]=1; image[20941]=1; image[20942]=1; image[20943]=1; image[20944]=1; image[20945]=1; image[20946]=1; image[20947]=1; image[20948]=1; image[20949]=1; image[20950]=1; image[20951]=1; image[20952]=1; image[20953]=1; image[20954]=1; image[20955]=1; image[20956]=1; image[20957]=1; image[20958]=1; image[20959]=1; image[20960]=1; image[20961]=1; image[20962]=1; image[20963]=1; image[20964]=1; image[20965]=1; image[20966]=1; image[20967]=1; image[20968]=1; image[20969]=2; image[20970]=2; image[20971]=6; image[20972]=10; image[20973]=15; image[20974]=13; image[20975]=10; image[20976]=6; image[20977]=8; image[20978]=8; image[20979]=8; image[20980]=12; image[20981]=20; image[20982]=22; image[20983]=22; image[20984]=18; image[20985]=13; image[20986]=5; image[20987]=4; image[20988]=13; image[20989]=24; image[20990]=22; image[20991]=24; image[20992]=32; image[20993]=31; image[20994]=31; image[20995]=32; image[20996]=39; image[20997]=42; image[20998]=44; image[20999]=43; image[21000]=39; image[21001]=41; image[21002]=43; image[21003]=50; image[21004]=49; image[21005]=47; image[21006]=30; image[21007]=18; image[21008]=35; image[21009]=36; image[21010]=36; image[21011]=39; image[21012]=33; image[21013]=78; image[21014]=95; image[21015]=80; image[21016]=188; image[21017]=186; image[21018]=198; image[21019]=199; image[21020]=242; image[21021]=88; image[21022]=48; image[21023]=126; image[21024]=132; image[21025]=138; image[21026]=103; image[21027]=98; image[21028]=125; image[21029]=189; image[21030]=241; image[21031]=252; image[21032]=255; image[21033]=224; image[21034]=116; image[21035]=152; image[21036]=204; image[21037]=165; image[21038]=121; image[21039]=77; image[21040]=82; image[21041]=150; image[21042]=188; image[21043]=170; image[21044]=248; image[21045]=255; image[21046]=255; image[21047]=202; image[21048]=215; image[21049]=178; image[21050]=29; image[21051]=25; image[21052]=4; image[21053]=2; image[21054]=1; image[21055]=1; image[21056]=1; image[21057]=1; image[21058]=1; image[21059]=1; image[21060]=1; image[21061]=1; image[21062]=1; image[21063]=1; image[21064]=1; image[21065]=1; image[21066]=1; image[21067]=1; image[21068]=1; image[21069]=1; image[21070]=1; image[21071]=1; image[21072]=1; image[21073]=1; image[21074]=1; image[21075]=1; image[21076]=1; image[21077]=1; image[21078]=1; image[21079]=1; image[21080]=1; image[21081]=1; image[21082]=1; image[21083]=1; image[21084]=1; image[21085]=1; image[21086]=1; image[21087]=1; image[21088]=1; image[21089]=1; image[21090]=1; image[21091]=1; image[21092]=1; image[21093]=1; image[21094]=1; image[21095]=1; image[21096]=1; image[21097]=1; image[21098]=1; image[21099]=1; image[21100]=1; image[21101]=1; image[21102]=1; image[21103]=1; image[21104]=1; image[21105]=1; image[21106]=1; image[21107]=1; image[21108]=1; image[21109]=1; image[21110]=2; image[21111]=1; image[21112]=1; image[21113]=1; image[21114]=1; image[21115]=1; image[21116]=1; image[21117]=1; image[21118]=1; image[21119]=1; image[21120]=1; image[21121]=1; image[21122]=1; image[21123]=1; image[21124]=1; image[21125]=1; image[21126]=1; image[21127]=1; image[21128]=1; image[21129]=1; image[21130]=1; image[21131]=1; image[21132]=1; image[21133]=1; image[21134]=1; image[21135]=1; image[21136]=1; image[21137]=1; image[21138]=1; image[21139]=1; image[21140]=1; image[21141]=1; image[21142]=1; image[21143]=1; image[21144]=1; image[21145]=1; image[21146]=1; image[21147]=1; image[21148]=1; image[21149]=1; image[21150]=1; image[21151]=1; image[21152]=1; image[21153]=1; image[21154]=1; image[21155]=1; image[21156]=1; image[21157]=1; image[21158]=1; image[21159]=1; image[21160]=1; image[21161]=1; image[21162]=1; image[21163]=1; image[21164]=1; image[21165]=1; image[21166]=1; image[21167]=1; image[21168]=2; image[21169]=3; image[21170]=6; image[21171]=9; image[21172]=12; image[21173]=13; image[21174]=10; image[21175]=7; image[21176]=9; image[21177]=8; image[21178]=9; image[21179]=9; image[21180]=17; image[21181]=23; image[21182]=21; image[21183]=23; image[21184]=12; image[21185]=2; image[21186]=6; image[21187]=16; image[21188]=25; image[21189]=24; image[21190]=25; image[21191]=27; image[21192]=28; image[21193]=27; image[21194]=31; image[21195]=35; image[21196]=34; image[21197]=36; image[21198]=47; image[21199]=45; image[21200]=40; image[21201]=53; image[21202]=55; image[21203]=61; image[21204]=64; image[21205]=41; image[21206]=15; image[21207]=33; image[21208]=39; image[21209]=42; image[21210]=37; image[21211]=32; image[21212]=85; image[21213]=99; image[21214]=71; image[21215]=186; image[21216]=209; image[21217]=214; image[21218]=206; image[21219]=240; image[21220]=99; image[21221]=15; image[21222]=105; image[21223]=140; image[21224]=180; image[21225]=172; image[21226]=142; image[21227]=99; image[21228]=127; image[21229]=191; image[21230]=241; image[21231]=253; image[21232]=255; image[21233]=227; image[21234]=195; image[21235]=188; image[21236]=172; image[21237]=136; image[21238]=68; image[21239]=79; image[21240]=168; image[21241]=191; image[21242]=171; image[21243]=244; image[21244]=255; image[21245]=255; image[21246]=237; image[21247]=231; image[21248]=212; image[21249]=40; image[21250]=26; image[21251]=4; image[21252]=2; image[21253]=1; image[21254]=1; image[21255]=1; image[21256]=1; image[21257]=1; image[21258]=1; image[21259]=1; image[21260]=1; image[21261]=1; image[21262]=1; image[21263]=1; image[21264]=1; image[21265]=1; image[21266]=1; image[21267]=1; image[21268]=1; image[21269]=1; image[21270]=1; image[21271]=1; image[21272]=1; image[21273]=1; image[21274]=1; image[21275]=1; image[21276]=1; image[21277]=1; image[21278]=1; image[21279]=1; image[21280]=1; image[21281]=1; image[21282]=1; image[21283]=1; image[21284]=1; image[21285]=1; image[21286]=1; image[21287]=1; image[21288]=1; image[21289]=1; image[21290]=1; image[21291]=1; image[21292]=1; image[21293]=1; image[21294]=1; image[21295]=1; image[21296]=1; image[21297]=1; image[21298]=1; image[21299]=1; image[21300]=1; image[21301]=1; image[21302]=1; image[21303]=1; image[21304]=1; image[21305]=1; image[21306]=1; image[21307]=1; image[21308]=1; image[21309]=1; image[21310]=1; image[21311]=1; image[21312]=1; image[21313]=1; image[21314]=1; image[21315]=1; image[21316]=1; image[21317]=1; image[21318]=1; image[21319]=1; image[21320]=1; image[21321]=1; image[21322]=1; image[21323]=1; image[21324]=1; image[21325]=1; image[21326]=1; image[21327]=1; image[21328]=1; image[21329]=1; image[21330]=1; image[21331]=1; image[21332]=1; image[21333]=1; image[21334]=1; image[21335]=1; image[21336]=1; image[21337]=1; image[21338]=1; image[21339]=1; image[21340]=1; image[21341]=1; image[21342]=1; image[21343]=1; image[21344]=1; image[21345]=1; image[21346]=1; image[21347]=1; image[21348]=1; image[21349]=1; image[21350]=1; image[21351]=1; image[21352]=1; image[21353]=1; image[21354]=1; image[21355]=1; image[21356]=1; image[21357]=1; image[21358]=1; image[21359]=1; image[21360]=1; image[21361]=1; image[21362]=1; image[21363]=1; image[21364]=1; image[21365]=1; image[21366]=2; image[21367]=2; image[21368]=4; image[21369]=5; image[21370]=9; image[21371]=14; image[21372]=13; image[21373]=9; image[21374]=7; image[21375]=8; image[21376]=8; image[21377]=8; image[21378]=8; image[21379]=16; image[21380]=21; image[21381]=21; image[21382]=21; image[21383]=11; image[21384]=3; image[21385]=9; image[21386]=15; image[21387]=16; image[21388]=18; image[21389]=19; image[21390]=23; image[21391]=23; image[21392]=22; image[21393]=28; image[21394]=28; image[21395]=27; image[21396]=30; image[21397]=37; image[21398]=38; image[21399]=34; image[21400]=42; image[21401]=44; image[21402]=40; image[21403]=44; image[21404]=39; image[21405]=12; image[21406]=23; image[21407]=34; image[21408]=41; image[21409]=37; image[21410]=36; image[21411]=81; image[21412]=100; image[21413]=69; image[21414]=169; image[21415]=210; image[21416]=209; image[21417]=209; image[21418]=206; image[21419]=72; image[21420]=4; image[21421]=81; image[21422]=149; image[21423]=188; image[21424]=195; image[21425]=193; image[21426]=164; image[21427]=155; image[21428]=188; image[21429]=248; image[21430]=241; image[21431]=237; image[21432]=255; image[21433]=250; image[21434]=176; image[21435]=139; image[21436]=131; image[21437]=62; image[21438]=79; image[21439]=176; image[21440]=217; image[21441]=204; image[21442]=253; image[21443]=255; image[21444]=255; image[21445]=255; image[21446]=220; image[21447]=200; image[21448]=40; image[21449]=26; image[21450]=3; image[21451]=2; image[21452]=1; image[21453]=1; image[21454]=1; image[21455]=1; image[21456]=1; image[21457]=1; image[21458]=1; image[21459]=1; image[21460]=1; image[21461]=1; image[21462]=1; image[21463]=1; image[21464]=1; image[21465]=1; image[21466]=1; image[21467]=1; image[21468]=1; image[21469]=1; image[21470]=1; image[21471]=1; image[21472]=1; image[21473]=1; image[21474]=1; image[21475]=1; image[21476]=1; image[21477]=1; image[21478]=1; image[21479]=1; image[21480]=1; image[21481]=1; image[21482]=1; image[21483]=1; image[21484]=1; image[21485]=1; image[21486]=1; image[21487]=1; image[21488]=1; image[21489]=1; image[21490]=1; image[21491]=1; image[21492]=1; image[21493]=1; image[21494]=1; image[21495]=1; image[21496]=1; image[21497]=1; image[21498]=1; image[21499]=1; image[21500]=1; image[21501]=1; image[21502]=1; image[21503]=1; image[21504]=1; image[21505]=1; image[21506]=1; image[21507]=2; image[21508]=2; image[21509]=1; image[21510]=1; image[21511]=1; image[21512]=1; image[21513]=1; image[21514]=1; image[21515]=1; image[21516]=1; image[21517]=1; image[21518]=1; image[21519]=1; image[21520]=1; image[21521]=1; image[21522]=1; image[21523]=1; image[21524]=1; image[21525]=1; image[21526]=1; image[21527]=1; image[21528]=1; image[21529]=1; image[21530]=1; image[21531]=1; image[21532]=1; image[21533]=1; image[21534]=1; image[21535]=1; image[21536]=1; image[21537]=1; image[21538]=1; image[21539]=1; image[21540]=1; image[21541]=1; image[21542]=1; image[21543]=1; image[21544]=1; image[21545]=1; image[21546]=1; image[21547]=1; image[21548]=1; image[21549]=1; image[21550]=1; image[21551]=1; image[21552]=1; image[21553]=1; image[21554]=2; image[21555]=1; image[21556]=1; image[21557]=1; image[21558]=1; image[21559]=1; image[21560]=1; image[21561]=1; image[21562]=1; image[21563]=1; image[21564]=2; image[21565]=2; image[21566]=3; image[21567]=3; image[21568]=5; image[21569]=8; image[21570]=14; image[21571]=13; image[21572]=9; image[21573]=8; image[21574]=9; image[21575]=8; image[21576]=8; image[21577]=11; image[21578]=18; image[21579]=22; image[21580]=23; image[21581]=20; image[21582]=10; image[21583]=3; image[21584]=11; image[21585]=15; image[21586]=14; image[21587]=14; image[21588]=12; image[21589]=18; image[21590]=18; image[21591]=17; image[21592]=22; image[21593]=24; image[21594]=26; image[21595]=29; image[21596]=28; image[21597]=28; image[21598]=32; image[21599]=36; image[21600]=41; image[21601]=33; image[21602]=32; image[21603]=34; image[21604]=10; image[21605]=22; image[21606]=33; image[21607]=39; image[21608]=35; image[21609]=35; image[21610]=79; image[21611]=107; image[21612]=69; image[21613]=156; image[21614]=209; image[21615]=203; image[21616]=218; image[21617]=205; image[21618]=65; image[21619]=0; image[21620]=50; image[21621]=154; image[21622]=192; image[21623]=196; image[21624]=220; image[21625]=233; image[21626]=218; image[21627]=204; image[21628]=250; image[21629]=242; image[21630]=210; image[21631]=255; image[21632]=255; image[21633]=182; image[21634]=115; image[21635]=126; image[21636]=59; image[21637]=90; image[21638]=198; image[21639]=251; image[21640]=230; image[21641]=254; image[21642]=255; image[21643]=255; image[21644]=255; image[21645]=237; image[21646]=220; image[21647]=32; image[21648]=21; image[21649]=2; image[21650]=2; image[21651]=1; image[21652]=1; image[21653]=1; image[21654]=1; image[21655]=1; image[21656]=1; image[21657]=1; image[21658]=1; image[21659]=1; image[21660]=1; image[21661]=1; image[21662]=1; image[21663]=1; image[21664]=1; image[21665]=1; image[21666]=1; image[21667]=1; image[21668]=1; image[21669]=1; image[21670]=1; image[21671]=1; image[21672]=1; image[21673]=1; image[21674]=1; image[21675]=1; image[21676]=1; image[21677]=1; image[21678]=1; image[21679]=1; image[21680]=1; image[21681]=1; image[21682]=1; image[21683]=1; image[21684]=1; image[21685]=1; image[21686]=1; image[21687]=1; image[21688]=1; image[21689]=1; image[21690]=1; image[21691]=1; image[21692]=1; image[21693]=1; image[21694]=1; image[21695]=1; image[21696]=1; image[21697]=2; image[21698]=1; image[21699]=1; image[21700]=1; image[21701]=1; image[21702]=1; image[21703]=1; image[21704]=1; image[21705]=1; image[21706]=1; image[21707]=1; image[21708]=1; image[21709]=1; image[21710]=1; image[21711]=1; image[21712]=1; image[21713]=1; image[21714]=1; image[21715]=1; image[21716]=1; image[21717]=1; image[21718]=1; image[21719]=1; image[21720]=1; image[21721]=1; image[21722]=1; image[21723]=1; image[21724]=1; image[21725]=1; image[21726]=1; image[21727]=1; image[21728]=1; image[21729]=1; image[21730]=1; image[21731]=1; image[21732]=1; image[21733]=1; image[21734]=1; image[21735]=1; image[21736]=1; image[21737]=1; image[21738]=1; image[21739]=1; image[21740]=1; image[21741]=1; image[21742]=1; image[21743]=1; image[21744]=1; image[21745]=1; image[21746]=1; image[21747]=1; image[21748]=1; image[21749]=1; image[21750]=1; image[21751]=1; image[21752]=1; image[21753]=2; image[21754]=1; image[21755]=1; image[21756]=1; image[21757]=1; image[21758]=1; image[21759]=1; image[21760]=1; image[21761]=1; image[21762]=2; image[21763]=2; image[21764]=2; image[21765]=3; image[21766]=5; image[21767]=7; image[21768]=8; image[21769]=11; image[21770]=12; image[21771]=9; image[21772]=8; image[21773]=9; image[21774]=7; image[21775]=9; image[21776]=14; image[21777]=24; image[21778]=25; image[21779]=22; image[21780]=20; image[21781]=12; image[21782]=5; image[21783]=8; image[21784]=9; image[21785]=7; image[21786]=10; image[21787]=10; image[21788]=10; image[21789]=11; image[21790]=11; image[21791]=15; image[21792]=18; image[21793]=21; image[21794]=20; image[21795]=22; image[21796]=20; image[21797]=20; image[21798]=19; image[21799]=15; image[21800]=15; image[21801]=21; image[21802]=28; image[21803]=8; image[21804]=21; image[21805]=35; image[21806]=38; image[21807]=38; image[21808]=37; image[21809]=82; image[21810]=104; image[21811]=65; image[21812]=148; image[21813]=192; image[21814]=208; image[21815]=236; image[21816]=252; image[21817]=69; image[21818]=0; image[21819]=12; image[21820]=116; image[21821]=200; image[21822]=175; image[21823]=220; image[21824]=254; image[21825]=251; image[21826]=255; image[21827]=252; image[21828]=237; image[21829]=230; image[21830]=255; image[21831]=255; image[21832]=255; image[21833]=95; image[21834]=71; image[21835]=44; image[21836]=132; image[21837]=255; image[21838]=240; image[21839]=233; image[21840]=254; image[21841]=255; image[21842]=252; image[21843]=253; image[21844]=255; image[21845]=213; image[21846]=34; image[21847]=23; image[21848]=2; image[21849]=2; image[21850]=1; image[21851]=1; image[21852]=1; image[21853]=1; image[21854]=1; image[21855]=1; image[21856]=1; image[21857]=1; image[21858]=1; image[21859]=1; image[21860]=1; image[21861]=1; image[21862]=1; image[21863]=1; image[21864]=1; image[21865]=1; image[21866]=1; image[21867]=1; image[21868]=1; image[21869]=1; image[21870]=1; image[21871]=1; image[21872]=1; image[21873]=1; image[21874]=1; image[21875]=1; image[21876]=1; image[21877]=1; image[21878]=1; image[21879]=1; image[21880]=1; image[21881]=1; image[21882]=1; image[21883]=1; image[21884]=1; image[21885]=1; image[21886]=1; image[21887]=1; image[21888]=1; image[21889]=1; image[21890]=1; image[21891]=1; image[21892]=1; image[21893]=1; image[21894]=1; image[21895]=1; image[21896]=1; image[21897]=1; image[21898]=1; image[21899]=1; image[21900]=1; image[21901]=1; image[21902]=1; image[21903]=1; image[21904]=1; image[21905]=1; image[21906]=1; image[21907]=1; image[21908]=1; image[21909]=1; image[21910]=1; image[21911]=1; image[21912]=1; image[21913]=1; image[21914]=1; image[21915]=1; image[21916]=1; image[21917]=1; image[21918]=1; image[21919]=1; image[21920]=1; image[21921]=1; image[21922]=1; image[21923]=1; image[21924]=1; image[21925]=1; image[21926]=1; image[21927]=1; image[21928]=1; image[21929]=1; image[21930]=1; image[21931]=1; image[21932]=1; image[21933]=1; image[21934]=1; image[21935]=1; image[21936]=1; image[21937]=1; image[21938]=1; image[21939]=1; image[21940]=1; image[21941]=1; image[21942]=1; image[21943]=1; image[21944]=1; image[21945]=1; image[21946]=1; image[21947]=1; image[21948]=1; image[21949]=1; image[21950]=1; image[21951]=1; image[21952]=1; image[21953]=1; image[21954]=1; image[21955]=1; image[21956]=2; image[21957]=1; image[21958]=1; image[21959]=1; image[21960]=1; image[21961]=1; image[21962]=2; image[21963]=2; image[21964]=4; image[21965]=5; image[21966]=7; image[21967]=8; image[21968]=10; image[21969]=11; image[21970]=9; image[21971]=8; image[21972]=9; image[21973]=8; image[21974]=8; image[21975]=12; image[21976]=22; image[21977]=22; image[21978]=20; image[21979]=18; image[21980]=10; image[21981]=5; image[21982]=7; image[21983]=7; image[21984]=6; image[21985]=9; image[21986]=10; image[21987]=8; image[21988]=9; image[21989]=10; image[21990]=10; image[21991]=12; image[21992]=15; image[21993]=15; image[21994]=16; image[21995]=14; image[21996]=13; image[21997]=12; image[21998]=9; image[21999]=13; image[22000]=17; image[22001]=19; image[22002]=7; image[22003]=18; image[22004]=36; image[22005]=39; image[22006]=39; image[22007]=35; image[22008]=76; image[22009]=102; image[22010]=59; image[22011]=136; image[22012]=185; image[22013]=205; image[22014]=219; image[22015]=248; image[22016]=75; image[22017]=0; image[22018]=3; image[22019]=62; image[22020]=175; image[22021]=174; image[22022]=181; image[22023]=221; image[22024]=244; image[22025]=255; image[22026]=254; image[22027]=227; image[22028]=213; image[22029]=240; image[22030]=255; image[22031]=255; image[22032]=150; image[22033]=60; image[22034]=50; image[22035]=161; image[22036]=255; image[22037]=238; image[22038]=242; image[22039]=255; image[22040]=255; image[22041]=247; image[22042]=249; image[22043]=255; image[22044]=189; image[22045]=33; image[22046]=22; image[22047]=3; image[22048]=2; image[22049]=1; image[22050]=1; image[22051]=1; image[22052]=1; image[22053]=1; image[22054]=1; image[22055]=1; image[22056]=1; image[22057]=1; image[22058]=1; image[22059]=1; image[22060]=1; image[22061]=1; image[22062]=1; image[22063]=1; image[22064]=1; image[22065]=1; image[22066]=1; image[22067]=1; image[22068]=1; image[22069]=1; image[22070]=1; image[22071]=1; image[22072]=1; image[22073]=1; image[22074]=1; image[22075]=1; image[22076]=1; image[22077]=1; image[22078]=1; image[22079]=1; image[22080]=1; image[22081]=1; image[22082]=1; image[22083]=1; image[22084]=1; image[22085]=1; image[22086]=1; image[22087]=1; image[22088]=1; image[22089]=1; image[22090]=1; image[22091]=1; image[22092]=1; image[22093]=2; image[22094]=2; image[22095]=1; image[22096]=1; image[22097]=1; image[22098]=1; image[22099]=1; image[22100]=1; image[22101]=1; image[22102]=1; image[22103]=1; image[22104]=1; image[22105]=1; image[22106]=1; image[22107]=1; image[22108]=1; image[22109]=1; image[22110]=1; image[22111]=1; image[22112]=1; image[22113]=1; image[22114]=1; image[22115]=1; image[22116]=1; image[22117]=1; image[22118]=1; image[22119]=1; image[22120]=1; image[22121]=1; image[22122]=1; image[22123]=1; image[22124]=1; image[22125]=1; image[22126]=1; image[22127]=1; image[22128]=1; image[22129]=1; image[22130]=1; image[22131]=1; image[22132]=1; image[22133]=1; image[22134]=1; image[22135]=1; image[22136]=1; image[22137]=1; image[22138]=1; image[22139]=1; image[22140]=1; image[22141]=1; image[22142]=1; image[22143]=1; image[22144]=1; image[22145]=1; image[22146]=1; image[22147]=1; image[22148]=1; image[22149]=2; image[22150]=2; image[22151]=1; image[22152]=1; image[22153]=1; image[22154]=2; image[22155]=2; image[22156]=1; image[22157]=2; image[22158]=1; image[22159]=1; image[22160]=1; image[22161]=1; image[22162]=2; image[22163]=3; image[22164]=6; image[22165]=6; image[22166]=6; image[22167]=8; image[22168]=9; image[22169]=9; image[22170]=8; image[22171]=8; image[22172]=9; image[22173]=8; image[22174]=10; image[22175]=20; image[22176]=18; image[22177]=15; image[22178]=17; image[22179]=9; image[22180]=2; image[22181]=3; image[22182]=3; image[22183]=4; image[22184]=4; image[22185]=4; image[22186]=5; image[22187]=8; image[22188]=11; image[22189]=10; image[22190]=12; image[22191]=16; image[22192]=14; image[22193]=14; image[22194]=14; image[22195]=8; image[22196]=6; image[22197]=6; image[22198]=8; image[22199]=9; image[22200]=9; image[22201]=6; image[22202]=19; image[22203]=36; image[22204]=37; image[22205]=38; image[22206]=33; image[22207]=76; image[22208]=106; image[22209]=55; image[22210]=132; image[22211]=201; image[22212]=200; image[22213]=185; image[22214]=204; image[22215]=66; image[22216]=0; image[22217]=2; image[22218]=18; image[22219]=101; image[22220]=147; image[22221]=152; image[22222]=190; image[22223]=249; image[22224]=255; image[22225]=250; image[22226]=207; image[22227]=171; image[22228]=195; image[22229]=254; image[22230]=255; image[22231]=226; image[22232]=91; image[22233]=69; image[22234]=216; image[22235]=255; image[22236]=244; image[22237]=240; image[22238]=255; image[22239]=255; image[22240]=233; image[22241]=245; image[22242]=237; image[22243]=140; image[22244]=42; image[22245]=19; image[22246]=4; image[22247]=2; image[22248]=1; image[22249]=1; image[22250]=1; image[22251]=1; image[22252]=1; image[22253]=1; image[22254]=1; image[22255]=1; image[22256]=1; image[22257]=1; image[22258]=1; image[22259]=1; image[22260]=1; image[22261]=1; image[22262]=1; image[22263]=1; image[22264]=1; image[22265]=1; image[22266]=1; image[22267]=1; image[22268]=1; image[22269]=1; image[22270]=1; image[22271]=1; image[22272]=1; image[22273]=1; image[22274]=1; image[22275]=1; image[22276]=1; image[22277]=1; image[22278]=1; image[22279]=1; image[22280]=1; image[22281]=1; image[22282]=1; image[22283]=1; image[22284]=1; image[22285]=1; image[22286]=1; image[22287]=1; image[22288]=1; image[22289]=1; image[22290]=1; image[22291]=1; image[22292]=1; image[22293]=1; image[22294]=1; image[22295]=1; image[22296]=1; image[22297]=1; image[22298]=1; image[22299]=1; image[22300]=1; image[22301]=1; image[22302]=1; image[22303]=1; image[22304]=1; image[22305]=1; image[22306]=1; image[22307]=1; image[22308]=1; image[22309]=1; image[22310]=1; image[22311]=1; image[22312]=1; image[22313]=1; image[22314]=1; image[22315]=1; image[22316]=1; image[22317]=1; image[22318]=1; image[22319]=1; image[22320]=1; image[22321]=1; image[22322]=1; image[22323]=1; image[22324]=1; image[22325]=1; image[22326]=1; image[22327]=1; image[22328]=1; image[22329]=1; image[22330]=1; image[22331]=1; image[22332]=1; image[22333]=1; image[22334]=1; image[22335]=1; image[22336]=1; image[22337]=1; image[22338]=1; image[22339]=1; image[22340]=1; image[22341]=1; image[22342]=1; image[22343]=1; image[22344]=1; image[22345]=1; image[22346]=1; image[22347]=2; image[22348]=1; image[22349]=1; image[22350]=2; image[22351]=1; image[22352]=2; image[22353]=1; image[22354]=1; image[22355]=1; image[22356]=1; image[22357]=1; image[22358]=1; image[22359]=1; image[22360]=1; image[22361]=2; image[22362]=3; image[22363]=4; image[22364]=5; image[22365]=5; image[22366]=7; image[22367]=9; image[22368]=8; image[22369]=9; image[22370]=9; image[22371]=9; image[22372]=10; image[22373]=12; image[22374]=18; image[22375]=15; image[22376]=13; image[22377]=16; image[22378]=10; image[22379]=7; image[22380]=11; image[22381]=13; image[22382]=16; image[22383]=22; image[22384]=30; image[22385]=38; image[22386]=37; image[22387]=34; image[22388]=35; image[22389]=35; image[22390]=36; image[22391]=44; image[22392]=46; image[22393]=54; image[22394]=45; image[22395]=38; image[22396]=29; image[22397]=22; image[22398]=14; image[22399]=7; image[22400]=7; image[22401]=23; image[22402]=37; image[22403]=35; image[22404]=38; image[22405]=36; image[22406]=70; image[22407]=98; image[22408]=54; image[22409]=115; image[22410]=195; image[22411]=210; image[22412]=196; image[22413]=152; image[22414]=58; image[22415]=6; image[22416]=6; image[22417]=18; image[22418]=85; image[22419]=152; image[22420]=139; image[22421]=146; image[22422]=210; image[22423]=246; image[22424]=253; image[22425]=240; image[22426]=227; image[22427]=168; image[22428]=222; image[22429]=255; image[22430]=249; image[22431]=164; image[22432]=103; image[22433]=200; image[22434]=255; image[22435]=228; image[22436]=223; image[22437]=254; image[22438]=251; image[22439]=215; image[22440]=244; image[22441]=237; image[22442]=81; image[22443]=40; image[22444]=22; image[22445]=3; image[22446]=1; image[22447]=1; image[22448]=1; image[22449]=1; image[22450]=1; image[22451]=1; image[22452]=1; image[22453]=1; image[22454]=1; image[22455]=1; image[22456]=1; image[22457]=1; image[22458]=1; image[22459]=1; image[22460]=1; image[22461]=1; image[22462]=1; image[22463]=1; image[22464]=1; image[22465]=1; image[22466]=1; image[22467]=1; image[22468]=1; image[22469]=2; image[22470]=1; image[22471]=1; image[22472]=1; image[22473]=1; image[22474]=1; image[22475]=1; image[22476]=1; image[22477]=1; image[22478]=1; image[22479]=1; image[22480]=1; image[22481]=1; image[22482]=1; image[22483]=1; image[22484]=1; image[22485]=1; image[22486]=1; image[22487]=1; image[22488]=1; image[22489]=1; image[22490]=1; image[22491]=1; image[22492]=1; image[22493]=1; image[22494]=1; image[22495]=1; image[22496]=1; image[22497]=1; image[22498]=1; image[22499]=1; image[22500]=1; image[22501]=1; image[22502]=1; image[22503]=1; image[22504]=1; image[22505]=1; image[22506]=1; image[22507]=1; image[22508]=1; image[22509]=1; image[22510]=1; image[22511]=1; image[22512]=1; image[22513]=1; image[22514]=1; image[22515]=1; image[22516]=1; image[22517]=1; image[22518]=1; image[22519]=1; image[22520]=1; image[22521]=1; image[22522]=1; image[22523]=1; image[22524]=1; image[22525]=1; image[22526]=1; image[22527]=1; image[22528]=1; image[22529]=1; image[22530]=1; image[22531]=1; image[22532]=1; image[22533]=1; image[22534]=1; image[22535]=1; image[22536]=1; image[22537]=1; image[22538]=1; image[22539]=1; image[22540]=1; image[22541]=1; image[22542]=1; image[22543]=1; image[22544]=1; image[22545]=1; image[22546]=1; image[22547]=1; image[22548]=1; image[22549]=1; image[22550]=2; image[22551]=2; image[22552]=2; image[22553]=2; image[22554]=2; image[22555]=1; image[22556]=1; image[22557]=1; image[22558]=1; image[22559]=1; image[22560]=2; image[22561]=2; image[22562]=4; image[22563]=4; image[22564]=5; image[22565]=5; image[22566]=8; image[22567]=7; image[22568]=8; image[22569]=9; image[22570]=9; image[22571]=12; image[22572]=12; image[22573]=15; image[22574]=15; image[22575]=11; image[22576]=14; image[22577]=11; image[22578]=7; image[22579]=11; image[22580]=14; image[22581]=17; image[22582]=25; image[22583]=34; image[22584]=41; image[22585]=39; image[22586]=37; image[22587]=42; image[22588]=42; image[22589]=41; image[22590]=49; image[22591]=47; image[22592]=52; image[22593]=55; image[22594]=61; image[22595]=51; image[22596]=34; image[22597]=18; image[22598]=8; image[22599]=6; image[22600]=19; image[22601]=37; image[22602]=34; image[22603]=34; image[22604]=34; image[22605]=68; image[22606]=96; image[22607]=56; image[22608]=115; image[22609]=198; image[22610]=203; image[22611]=192; image[22612]=116; image[22613]=43; image[22614]=8; image[22615]=9; image[22616]=19; image[22617]=64; image[22618]=152; image[22619]=144; image[22620]=124; image[22621]=164; image[22622]=210; image[22623]=249; image[22624]=236; image[22625]=232; image[22626]=174; image[22627]=179; image[22628]=252; image[22629]=255; image[22630]=208; image[22631]=132; image[22632]=151; image[22633]=242; image[22634]=225; image[22635]=213; image[22636]=254; image[22637]=253; image[22638]=223; image[22639]=223; image[22640]=255; image[22641]=111; image[22642]=33; image[22643]=19; image[22644]=3; image[22645]=1; image[22646]=1; image[22647]=1; image[22648]=1; image[22649]=1; image[22650]=1; image[22651]=1; image[22652]=1; image[22653]=1; image[22654]=1; image[22655]=1; image[22656]=1; image[22657]=1; image[22658]=1; image[22659]=1; image[22660]=1; image[22661]=1; image[22662]=1; image[22663]=1; image[22664]=1; image[22665]=1; image[22666]=1; image[22667]=1; image[22668]=2; image[22669]=2; image[22670]=2; image[22671]=1; image[22672]=1; image[22673]=1; image[22674]=1; image[22675]=1; image[22676]=1; image[22677]=1; image[22678]=1; image[22679]=1; image[22680]=1; image[22681]=1; image[22682]=1; image[22683]=1; image[22684]=1; image[22685]=1; image[22686]=1; image[22687]=1; image[22688]=1; image[22689]=1; image[22690]=1; image[22691]=1; image[22692]=1; image[22693]=1; image[22694]=1; image[22695]=1; image[22696]=1; image[22697]=1; image[22698]=1; image[22699]=1; image[22700]=1; image[22701]=1; image[22702]=1; image[22703]=1; image[22704]=1; image[22705]=1; image[22706]=1; image[22707]=1; image[22708]=1; image[22709]=1; image[22710]=1; image[22711]=1; image[22712]=1; image[22713]=1; image[22714]=1; image[22715]=1; image[22716]=1; image[22717]=1; image[22718]=1; image[22719]=1; image[22720]=1; image[22721]=1; image[22722]=1; image[22723]=1; image[22724]=1; image[22725]=1; image[22726]=1; image[22727]=1; image[22728]=1; image[22729]=1; image[22730]=1; image[22731]=1; image[22732]=1; image[22733]=1; image[22734]=1; image[22735]=1; image[22736]=1; image[22737]=1; image[22738]=1; image[22739]=1; image[22740]=1; image[22741]=1; image[22742]=1; image[22743]=1; image[22744]=1; image[22745]=1; image[22746]=1; image[22747]=1; image[22748]=1; image[22749]=2; image[22750]=2; image[22751]=2; image[22752]=2; image[22753]=1; image[22754]=1; image[22755]=1; image[22756]=1; image[22757]=1; image[22758]=1; image[22759]=1; image[22760]=1; image[22761]=2; image[22762]=2; image[22763]=3; image[22764]=4; image[22765]=6; image[22766]=7; image[22767]=8; image[22768]=8; image[22769]=11; image[22770]=11; image[22771]=11; image[22772]=15; image[22773]=13; image[22774]=13; image[22775]=20; image[22776]=13; image[22777]=4; image[22778]=6; image[22779]=7; image[22780]=10; image[22781]=16; image[22782]=26; image[22783]=42; image[22784]=39; image[22785]=40; image[22786]=46; image[22787]=50; image[22788]=43; image[22789]=45; image[22790]=56; image[22791]=54; image[22792]=43; image[22793]=33; image[22794]=18; image[22795]=7; image[22796]=6; image[22797]=7; image[22798]=5; image[22799]=13; image[22800]=34; image[22801]=37; image[22802]=36; image[22803]=34; image[22804]=66; image[22805]=99; image[22806]=65; image[22807]=116; image[22808]=205; image[22809]=205; image[22810]=185; image[22811]=118; image[22812]=39; image[22813]=8; image[22814]=10; image[22815]=29; image[22816]=42; image[22817]=87; image[22818]=117; image[22819]=109; image[22820]=139; image[22821]=138; image[22822]=136; image[22823]=157; image[22824]=169; image[22825]=204; image[22826]=172; image[22827]=177; image[22828]=255; image[22829]=255; image[22830]=232; image[22831]=132; image[22832]=223; image[22833]=252; image[22834]=215; image[22835]=253; image[22836]=255; image[22837]=235; image[22838]=181; image[22839]=255; image[22840]=112; image[22841]=37; image[22842]=24; image[22843]=4; image[22844]=1; image[22845]=1; image[22846]=1; image[22847]=1; image[22848]=1; image[22849]=1; image[22850]=1; image[22851]=1; image[22852]=1; image[22853]=1; image[22854]=1; image[22855]=1; image[22856]=1; image[22857]=1; image[22858]=1; image[22859]=1; image[22860]=1; image[22861]=1; image[22862]=1; image[22863]=1; image[22864]=1; image[22865]=1; image[22866]=1; image[22867]=1; image[22868]=1; image[22869]=1; image[22870]=1; image[22871]=1; image[22872]=1; image[22873]=1; image[22874]=1; image[22875]=1; image[22876]=1; image[22877]=1; image[22878]=1; image[22879]=1; image[22880]=1; image[22881]=1; image[22882]=1; image[22883]=1; image[22884]=1; image[22885]=1; image[22886]=1; image[22887]=1; image[22888]=1; image[22889]=1; image[22890]=1; image[22891]=1; image[22892]=1; image[22893]=1; image[22894]=1; image[22895]=1; image[22896]=1; image[22897]=1; image[22898]=1; image[22899]=1; image[22900]=1; image[22901]=1; image[22902]=1; image[22903]=1; image[22904]=1; image[22905]=1; image[22906]=1; image[22907]=1; image[22908]=1; image[22909]=1; image[22910]=1; image[22911]=1; image[22912]=1; image[22913]=1; image[22914]=1; image[22915]=1; image[22916]=1; image[22917]=1; image[22918]=1; image[22919]=1; image[22920]=1; image[22921]=1; image[22922]=1; image[22923]=1; image[22924]=1; image[22925]=1; image[22926]=1; image[22927]=1; image[22928]=1; image[22929]=1; image[22930]=1; image[22931]=1; image[22932]=1; image[22933]=1; image[22934]=1; image[22935]=1; image[22936]=1; image[22937]=1; image[22938]=1; image[22939]=1; image[22940]=1; image[22941]=1; image[22942]=1; image[22943]=1; image[22944]=1; image[22945]=1; image[22946]=1; image[22947]=1; image[22948]=1; image[22949]=1; image[22950]=1; image[22951]=1; image[22952]=1; image[22953]=1; image[22954]=1; image[22955]=1; image[22956]=1; image[22957]=1; image[22958]=1; image[22959]=1; image[22960]=1; image[22961]=1; image[22962]=2; image[22963]=2; image[22964]=5; image[22965]=7; image[22966]=7; image[22967]=7; image[22968]=10; image[22969]=9; image[22970]=11; image[22971]=14; image[22972]=10; image[22973]=9; image[22974]=10; image[22975]=8; image[22976]=5; image[22977]=7; image[22978]=7; image[22979]=8; image[22980]=8; image[22981]=10; image[22982]=19; image[22983]=23; image[22984]=27; image[22985]=30; image[22986]=33; image[22987]=29; image[22988]=30; image[22989]=31; image[22990]=25; image[22991]=20; image[22992]=15; image[22993]=15; image[22994]=14; image[22995]=14; image[22996]=22; image[22997]=13; image[22998]=13; image[22999]=35; image[23000]=40; image[23001]=38; image[23002]=36; image[23003]=70; image[23004]=96; image[23005]=62; image[23006]=105; image[23007]=204; image[23008]=218; image[23009]=188; image[23010]=112; image[23011]=41; image[23012]=11; image[23013]=14; image[23014]=52; image[23015]=100; image[23016]=83; image[23017]=120; image[23018]=115; image[23019]=133; image[23020]=100; image[23021]=98; image[23022]=149; image[23023]=167; image[23024]=176; image[23025]=199; image[23026]=165; image[23027]=243; image[23028]=255; image[23029]=255; image[23030]=143; image[23031]=212; image[23032]=255; image[23033]=240; image[23034]=254; image[23035]=255; image[23036]=229; image[23037]=132; image[23038]=233; image[23039]=98; image[23040]=35; image[23041]=21; image[23042]=4; image[23043]=1; image[23044]=1; image[23045]=1; image[23046]=1; image[23047]=1; image[23048]=1; image[23049]=1; image[23050]=1; image[23051]=1; image[23052]=1; image[23053]=1; image[23054]=1; image[23055]=1; image[23056]=1; image[23057]=1; image[23058]=1; image[23059]=1; image[23060]=1; image[23061]=1; image[23062]=1; image[23063]=1; image[23064]=1; image[23065]=1; image[23066]=1; image[23067]=1; image[23068]=1; image[23069]=1; image[23070]=1; image[23071]=1; image[23072]=1; image[23073]=1; image[23074]=1; image[23075]=1; image[23076]=1; image[23077]=1; image[23078]=1; image[23079]=1; image[23080]=1; image[23081]=1; image[23082]=1; image[23083]=1; image[23084]=1; image[23085]=1; image[23086]=1; image[23087]=1; image[23088]=1; image[23089]=1; image[23090]=1; image[23091]=1; image[23092]=1; image[23093]=1; image[23094]=1; image[23095]=1; image[23096]=1; image[23097]=1; image[23098]=1; image[23099]=1; image[23100]=1; image[23101]=1; image[23102]=1; image[23103]=1; image[23104]=1; image[23105]=1; image[23106]=1; image[23107]=1; image[23108]=1; image[23109]=1; image[23110]=1; image[23111]=1; image[23112]=1; image[23113]=1; image[23114]=1; image[23115]=1; image[23116]=1; image[23117]=1; image[23118]=1; image[23119]=1; image[23120]=1; image[23121]=1; image[23122]=1; image[23123]=1; image[23124]=1; image[23125]=1; image[23126]=1; image[23127]=1; image[23128]=1; image[23129]=1; image[23130]=1; image[23131]=1; image[23132]=1; image[23133]=1; image[23134]=1; image[23135]=1; image[23136]=1; image[23137]=1; image[23138]=1; image[23139]=1; image[23140]=1; image[23141]=1; image[23142]=1; image[23143]=1; image[23144]=1; image[23145]=1; image[23146]=1; image[23147]=1; image[23148]=1; image[23149]=1; image[23150]=1; image[23151]=1; image[23152]=1; image[23153]=1; image[23154]=1; image[23155]=1; image[23156]=1; image[23157]=1; image[23158]=1; image[23159]=1; image[23160]=1; image[23161]=1; image[23162]=2; image[23163]=3; image[23164]=6; image[23165]=7; image[23166]=8; image[23167]=9; image[23168]=9; image[23169]=10; image[23170]=11; image[23171]=8; image[23172]=6; image[23173]=5; image[23174]=5; image[23175]=10; image[23176]=13; image[23177]=16; image[23178]=16; image[23179]=13; image[23180]=9; image[23181]=7; image[23182]=8; image[23183]=11; image[23184]=13; image[23185]=14; image[23186]=13; image[23187]=15; image[23188]=15; image[23189]=15; image[23190]=22; image[23191]=24; image[23192]=25; image[23193]=21; image[23194]=17; image[23195]=25; image[23196]=15; image[23197]=12; image[23198]=36; image[23199]=45; image[23200]=43; image[23201]=43; image[23202]=77; image[23203]=97; image[23204]=58; image[23205]=100; image[23206]=210; image[23207]=223; image[23208]=184; image[23209]=96; image[23210]=42; image[23211]=14; image[23212]=17; image[23213]=68; image[23214]=179; image[23215]=83; image[23216]=91; image[23217]=110; image[23218]=155; image[23219]=120; image[23220]=112; image[23221]=154; image[23222]=172; image[23223]=158; image[23224]=220; image[23225]=183; image[23226]=218; image[23227]=255; image[23228]=255; image[23229]=170; image[23230]=200; image[23231]=255; image[23232]=255; image[23233]=255; image[23234]=255; image[23235]=236; image[23236]=105; image[23237]=207; image[23238]=123; image[23239]=33; image[23240]=20; image[23241]=3; image[23242]=1; image[23243]=1; image[23244]=1; image[23245]=1; image[23246]=1; image[23247]=1; image[23248]=1; image[23249]=1; image[23250]=1; image[23251]=1; image[23252]=1; image[23253]=1; image[23254]=1; image[23255]=1; image[23256]=1; image[23257]=1; image[23258]=1; image[23259]=1; image[23260]=1; image[23261]=1; image[23262]=1; image[23263]=1; image[23264]=1; image[23265]=1; image[23266]=1; image[23267]=1; image[23268]=1; image[23269]=1; image[23270]=1; image[23271]=1; image[23272]=1; image[23273]=1; image[23274]=1; image[23275]=1; image[23276]=1; image[23277]=1; image[23278]=1; image[23279]=1; image[23280]=1; image[23281]=1; image[23282]=1; image[23283]=1; image[23284]=1; image[23285]=1; image[23286]=1; image[23287]=1; image[23288]=1; image[23289]=1; image[23290]=1; image[23291]=1; image[23292]=1; image[23293]=1; image[23294]=1; image[23295]=1; image[23296]=1; image[23297]=1; image[23298]=1; image[23299]=1; image[23300]=1; image[23301]=1; image[23302]=1; image[23303]=1; image[23304]=1; image[23305]=1; image[23306]=1; image[23307]=1; image[23308]=1; image[23309]=1; image[23310]=1; image[23311]=1; image[23312]=1; image[23313]=1; image[23314]=1; image[23315]=1; image[23316]=1; image[23317]=1; image[23318]=1; image[23319]=1; image[23320]=1; image[23321]=1; image[23322]=1; image[23323]=1; image[23324]=1; image[23325]=1; image[23326]=1; image[23327]=1; image[23328]=1; image[23329]=1; image[23330]=1; image[23331]=1; image[23332]=1; image[23333]=1; image[23334]=1; image[23335]=1; image[23336]=1; image[23337]=1; image[23338]=1; image[23339]=1; image[23340]=1; image[23341]=1; image[23342]=1; image[23343]=1; image[23344]=1; image[23345]=1; image[23346]=1; image[23347]=1; image[23348]=1; image[23349]=1; image[23350]=1; image[23351]=1; image[23352]=1; image[23353]=1; image[23354]=1; image[23355]=1; image[23356]=1; image[23357]=1; image[23358]=1; image[23359]=1; image[23360]=1; image[23361]=1; image[23362]=1; image[23363]=3; image[23364]=6; image[23365]=6; image[23366]=8; image[23367]=8; image[23368]=9; image[23369]=11; image[23370]=7; image[23371]=5; image[23372]=5; image[23373]=4; image[23374]=7; image[23375]=9; image[23376]=10; image[23377]=16; image[23378]=18; image[23379]=17; image[23380]=20; image[23381]=18; image[23382]=19; image[23383]=20; image[23384]=20; image[23385]=23; image[23386]=26; image[23387]=23; image[23388]=25; image[23389]=32; image[23390]=36; image[23391]=33; image[23392]=21; image[23393]=18; image[23394]=25; image[23395]=15; image[23396]=13; image[23397]=31; image[23398]=40; image[23399]=40; image[23400]=42; image[23401]=73; image[23402]=101; image[23403]=64; image[23404]=100; image[23405]=204; image[23406]=194; image[23407]=170; image[23408]=63; image[23409]=24; image[23410]=12; image[23411]=21; image[23412]=86; image[23413]=255; image[23414]=179; image[23415]=100; image[23416]=143; image[23417]=130; image[23418]=134; image[23419]=142; image[23420]=120; image[23421]=128; image[23422]=145; image[23423]=186; image[23424]=166; image[23425]=196; image[23426]=248; image[23427]=250; image[23428]=201; image[23429]=202; image[23430]=237; image[23431]=230; image[23432]=254; image[23433]=255; image[23434]=239; image[23435]=133; image[23436]=236; image[23437]=177; image[23438]=32; image[23439]=19; image[23440]=4; image[23441]=2; image[23442]=1; image[23443]=1; image[23444]=1; image[23445]=1; image[23446]=1; image[23447]=1; image[23448]=1; image[23449]=1; image[23450]=1; image[23451]=1; image[23452]=1; image[23453]=1; image[23454]=1; image[23455]=1; image[23456]=1; image[23457]=1; image[23458]=1; image[23459]=1; image[23460]=1; image[23461]=1; image[23462]=1; image[23463]=1; image[23464]=1; image[23465]=1; image[23466]=1; image[23467]=1; image[23468]=1; image[23469]=1; image[23470]=1; image[23471]=1; image[23472]=1; image[23473]=1; image[23474]=1; image[23475]=1; image[23476]=1; image[23477]=1; image[23478]=1; image[23479]=1; image[23480]=1; image[23481]=1; image[23482]=1; image[23483]=1; image[23484]=1; image[23485]=1; image[23486]=1; image[23487]=1; image[23488]=1; image[23489]=1; image[23490]=1; image[23491]=1; image[23492]=1; image[23493]=1; image[23494]=1; image[23495]=1; image[23496]=1; image[23497]=1; image[23498]=1; image[23499]=1; image[23500]=1; image[23501]=1; image[23502]=1; image[23503]=1; image[23504]=1; image[23505]=1; image[23506]=1; image[23507]=1; image[23508]=1; image[23509]=1; image[23510]=1; image[23511]=1; image[23512]=1; image[23513]=1; image[23514]=1; image[23515]=1; image[23516]=1; image[23517]=1; image[23518]=1; image[23519]=1; image[23520]=1; image[23521]=1; image[23522]=1; image[23523]=1; image[23524]=1; image[23525]=1; image[23526]=1; image[23527]=1; image[23528]=1; image[23529]=1; image[23530]=1; image[23531]=1; image[23532]=1; image[23533]=1; image[23534]=1; image[23535]=1; image[23536]=1; image[23537]=1; image[23538]=1; image[23539]=1; image[23540]=1; image[23541]=1; image[23542]=1; image[23543]=1; image[23544]=1; image[23545]=1; image[23546]=1; image[23547]=1; image[23548]=1; image[23549]=1; image[23550]=1; image[23551]=1; image[23552]=1; image[23553]=1; image[23554]=1; image[23555]=1; image[23556]=1; image[23557]=1; image[23558]=1; image[23559]=1; image[23560]=1; image[23561]=1; image[23562]=1; image[23563]=4; image[23564]=6; image[23565]=8; image[23566]=8; image[23567]=8; image[23568]=9; image[23569]=7; image[23570]=4; image[23571]=5; image[23572]=5; image[23573]=6; image[23574]=7; image[23575]=9; image[23576]=15; image[23577]=15; image[23578]=15; image[23579]=22; image[23580]=21; image[23581]=23; image[23582]=28; image[23583]=29; image[23584]=30; image[23585]=29; image[23586]=26; image[23587]=29; image[23588]=36; image[23589]=42; image[23590]=39; image[23591]=29; image[23592]=18; image[23593]=22; image[23594]=15; image[23595]=12; image[23596]=31; image[23597]=41; image[23598]=42; image[23599]=40; image[23600]=75; image[23601]=104; image[23602]=68; image[23603]=95; image[23604]=200; image[23605]=195; image[23606]=166; image[23607]=47; image[23608]=13; image[23609]=9; image[23610]=20; image[23611]=93; image[23612]=255; image[23613]=228; image[23614]=135; image[23615]=138; image[23616]=121; image[23617]=107; image[23618]=109; image[23619]=112; image[23620]=139; image[23621]=191; image[23622]=224; image[23623]=170; image[23624]=183; image[23625]=225; image[23626]=223; image[23627]=193; image[23628]=213; image[23629]=245; image[23630]=217; image[23631]=243; image[23632]=255; image[23633]=238; image[23634]=146; image[23635]=248; image[23636]=156; image[23637]=32; image[23638]=18; image[23639]=4; image[23640]=2; image[23641]=1; image[23642]=1; image[23643]=1; image[23644]=1; image[23645]=1; image[23646]=1; image[23647]=1; image[23648]=1; image[23649]=1; image[23650]=1; image[23651]=1; image[23652]=1; image[23653]=1; image[23654]=1; image[23655]=1; image[23656]=1; image[23657]=1; image[23658]=1; image[23659]=1; image[23660]=1; image[23661]=1; image[23662]=1; image[23663]=1; image[23664]=1; image[23665]=1; image[23666]=1; image[23667]=1; image[23668]=1; image[23669]=1; image[23670]=1; image[23671]=1; image[23672]=1; image[23673]=1; image[23674]=1; image[23675]=1; image[23676]=1; image[23677]=1; image[23678]=1; image[23679]=1; image[23680]=1; image[23681]=1; image[23682]=1; image[23683]=1; image[23684]=1; image[23685]=1; image[23686]=1; image[23687]=1; image[23688]=1; image[23689]=1; image[23690]=1; image[23691]=1; image[23692]=1; image[23693]=1; image[23694]=1; image[23695]=1; image[23696]=1; image[23697]=1; image[23698]=1; image[23699]=1; image[23700]=1; image[23701]=1; image[23702]=1; image[23703]=1; image[23704]=1; image[23705]=1; image[23706]=1; image[23707]=1; image[23708]=1; image[23709]=1; image[23710]=1; image[23711]=1; image[23712]=1; image[23713]=1; image[23714]=1; image[23715]=1; image[23716]=1; image[23717]=1; image[23718]=1; image[23719]=1; image[23720]=1; image[23721]=1; image[23722]=1; image[23723]=1; image[23724]=1; image[23725]=1; image[23726]=1; image[23727]=1; image[23728]=1; image[23729]=1; image[23730]=1; image[23731]=1; image[23732]=1; image[23733]=1; image[23734]=1; image[23735]=1; image[23736]=1; image[23737]=1; image[23738]=1; image[23739]=1; image[23740]=1; image[23741]=1; image[23742]=1; image[23743]=1; image[23744]=1; image[23745]=1; image[23746]=1; image[23747]=1; image[23748]=1; image[23749]=1; image[23750]=1; image[23751]=1; image[23752]=1; image[23753]=1; image[23754]=1; image[23755]=1; image[23756]=1; image[23757]=1; image[23758]=1; image[23759]=1; image[23760]=1; image[23761]=1; image[23762]=3; image[23763]=5; image[23764]=6; image[23765]=6; image[23766]=7; image[23767]=8; image[23768]=5; image[23769]=2; image[23770]=3; image[23771]=5; image[23772]=5; image[23773]=10; image[23774]=14; image[23775]=19; image[23776]=20; image[23777]=21; image[23778]=26; image[23779]=26; image[23780]=28; image[23781]=33; image[23782]=38; image[23783]=35; image[23784]=29; image[23785]=33; image[23786]=41; image[23787]=46; image[23788]=47; image[23789]=45; image[23790]=40; image[23791]=22; image[23792]=25; image[23793]=16; image[23794]=10; image[23795]=33; image[23796]=41; image[23797]=42; image[23798]=44; image[23799]=72; image[23800]=96; image[23801]=74; image[23802]=93; image[23803]=193; image[23804]=201; image[23805]=160; image[23806]=48; image[23807]=8; image[23808]=2; image[23809]=4; image[23810]=47; image[23811]=218; image[23812]=255; image[23813]=169; image[23814]=117; image[23815]=201; image[23816]=201; image[23817]=127; image[23818]=137; image[23819]=163; image[23820]=193; image[23821]=208; image[23822]=158; image[23823]=167; image[23824]=220; image[23825]=203; image[23826]=186; image[23827]=223; image[23828]=255; image[23829]=223; image[23830]=241; image[23831]=255; image[23832]=248; image[23833]=159; image[23834]=242; image[23835]=109; image[23836]=26; image[23837]=14; image[23838]=3; image[23839]=1; image[23840]=1; image[23841]=1; image[23842]=1; image[23843]=1; image[23844]=1; image[23845]=1; image[23846]=1; image[23847]=1; image[23848]=1; image[23849]=1; image[23850]=1; image[23851]=1; image[23852]=1; image[23853]=1; image[23854]=1; image[23855]=1; image[23856]=1; image[23857]=1; image[23858]=1; image[23859]=1; image[23860]=1; image[23861]=1; image[23862]=1; image[23863]=1; image[23864]=1; image[23865]=1; image[23866]=1; image[23867]=1; image[23868]=1; image[23869]=1; image[23870]=1; image[23871]=1; image[23872]=1; image[23873]=1; image[23874]=1; image[23875]=1; image[23876]=1; image[23877]=1; image[23878]=1; image[23879]=1; image[23880]=1; image[23881]=1; image[23882]=1; image[23883]=1; image[23884]=1; image[23885]=1; image[23886]=1; image[23887]=1; image[23888]=1; image[23889]=1; image[23890]=1; image[23891]=1; image[23892]=1; image[23893]=1; image[23894]=1; image[23895]=1; image[23896]=1; image[23897]=1; image[23898]=1; image[23899]=1; image[23900]=1; image[23901]=1; image[23902]=1; image[23903]=1; image[23904]=1; image[23905]=1; image[23906]=1; image[23907]=1; image[23908]=1; image[23909]=1; image[23910]=1; image[23911]=1; image[23912]=1; image[23913]=1; image[23914]=1; image[23915]=1; image[23916]=1; image[23917]=1; image[23918]=1; image[23919]=1; image[23920]=1; image[23921]=1; image[23922]=1; image[23923]=1; image[23924]=1; image[23925]=1; image[23926]=1; image[23927]=1; image[23928]=1; image[23929]=1; image[23930]=1; image[23931]=1; image[23932]=1; image[23933]=1; image[23934]=1; image[23935]=1; image[23936]=1; image[23937]=1; image[23938]=1; image[23939]=1; image[23940]=1; image[23941]=1; image[23942]=1; image[23943]=1; image[23944]=1; image[23945]=1; image[23946]=1; image[23947]=1; image[23948]=1; image[23949]=1; image[23950]=1; image[23951]=1; image[23952]=1; image[23953]=1; image[23954]=1; image[23955]=1; image[23956]=1; image[23957]=1; image[23958]=1; image[23959]=1; image[23960]=1; image[23961]=2; image[23962]=5; image[23963]=7; image[23964]=7; image[23965]=8; image[23966]=9; image[23967]=6; image[23968]=3; image[23969]=3; image[23970]=5; image[23971]=6; image[23972]=7; image[23973]=15; image[23974]=25; image[23975]=23; image[23976]=25; image[23977]=22; image[23978]=20; image[23979]=22; image[23980]=34; image[23981]=34; image[23982]=30; image[23983]=33; image[23984]=37; image[23985]=40; image[23986]=43; image[23987]=45; image[23988]=40; image[23989]=36; image[23990]=34; image[23991]=29; image[23992]=14; image[23993]=11; image[23994]=31; image[23995]=39; image[23996]=45; image[23997]=50; image[23998]=79; image[23999]=99; image[24000]=72; image[24001]=99; image[24002]=185; image[24003]=193; image[24004]=154; image[24005]=47; image[24006]=7; image[24007]=4; image[24008]=4; image[24009]=15; image[24010]=109; image[24011]=255; image[24012]=235; image[24013]=137; image[24014]=129; image[24015]=193; image[24016]=210; image[24017]=162; image[24018]=130; image[24019]=159; image[24020]=205; image[24021]=213; image[24022]=140; image[24023]=181; image[24024]=185; image[24025]=163; image[24026]=217; image[24027]=254; image[24028]=234; image[24029]=249; image[24030]=255; image[24031]=246; image[24032]=164; image[24033]=253; image[24034]=84; image[24035]=25; image[24036]=13; image[24037]=2; image[24038]=1; image[24039]=1; image[24040]=1; image[24041]=1; image[24042]=1; image[24043]=1; image[24044]=1; image[24045]=1; image[24046]=1; image[24047]=1; image[24048]=1; image[24049]=1; image[24050]=1; image[24051]=1; image[24052]=1; image[24053]=1; image[24054]=1; image[24055]=1; image[24056]=1; image[24057]=1; image[24058]=1; image[24059]=1; image[24060]=1; image[24061]=1; image[24062]=1; image[24063]=1; image[24064]=1; image[24065]=1; image[24066]=1; image[24067]=1; image[24068]=1; image[24069]=1; image[24070]=1; image[24071]=1; image[24072]=1; image[24073]=1; image[24074]=1; image[24075]=1; image[24076]=1; image[24077]=1; image[24078]=1; image[24079]=1; image[24080]=1; image[24081]=1; image[24082]=1; image[24083]=1; image[24084]=1; image[24085]=1; image[24086]=1; image[24087]=1; image[24088]=1; image[24089]=1; image[24090]=1; image[24091]=1; image[24092]=1; image[24093]=1; image[24094]=1; image[24095]=1; image[24096]=1; image[24097]=1; image[24098]=1; image[24099]=1; image[24100]=1; image[24101]=1; image[24102]=1; image[24103]=1; image[24104]=1; image[24105]=1; image[24106]=1; image[24107]=1; image[24108]=1; image[24109]=1; image[24110]=1; image[24111]=1; image[24112]=1; image[24113]=1; image[24114]=1; image[24115]=1; image[24116]=1; image[24117]=1; image[24118]=1; image[24119]=1; image[24120]=1; image[24121]=1; image[24122]=1; image[24123]=1; image[24124]=1; image[24125]=1; image[24126]=1; image[24127]=1; image[24128]=1; image[24129]=1; image[24130]=1; image[24131]=1; image[24132]=1; image[24133]=1; image[24134]=1; image[24135]=1; image[24136]=1; image[24137]=1; image[24138]=1; image[24139]=1; image[24140]=1; image[24141]=1; image[24142]=1; image[24143]=1; image[24144]=1; image[24145]=1; image[24146]=1; image[24147]=1; image[24148]=1; image[24149]=1; image[24150]=1; image[24151]=1; image[24152]=1; image[24153]=1; image[24154]=1; image[24155]=1; image[24156]=1; image[24157]=1; image[24158]=1; image[24159]=1; image[24160]=2; image[24161]=3; image[24162]=5; image[24163]=9; image[24164]=8; image[24165]=9; image[24166]=7; image[24167]=3; image[24168]=3; image[24169]=6; image[24170]=8; image[24171]=8; image[24172]=17; image[24173]=26; image[24174]=26; image[24175]=29; image[24176]=26; image[24177]=26; image[24178]=25; image[24179]=36; image[24180]=33; image[24181]=37; image[24182]=40; image[24183]=36; image[24184]=41; image[24185]=42; image[24186]=43; image[24187]=39; image[24188]=36; image[24189]=39; image[24190]=32; image[24191]=16; image[24192]=12; image[24193]=28; image[24194]=37; image[24195]=41; image[24196]=49; image[24197]=77; image[24198]=100; image[24199]=72; image[24200]=97; image[24201]=185; image[24202]=195; image[24203]=156; image[24204]=45; image[24205]=10; image[24206]=16; image[24207]=11; image[24208]=12; image[24209]=70; image[24210]=234; image[24211]=255; image[24212]=177; image[24213]=92; image[24214]=115; image[24215]=201; image[24216]=225; image[24217]=170; image[24218]=223; image[24219]=237; image[24220]=255; image[24221]=180; image[24222]=143; image[24223]=175; image[24224]=167; image[24225]=222; image[24226]=255; image[24227]=231; image[24228]=226; image[24229]=255; image[24230]=244; image[24231]=153; image[24232]=243; image[24233]=73; image[24234]=28; image[24235]=12; image[24236]=2; image[24237]=1; image[24238]=2; image[24239]=1; image[24240]=1; image[24241]=1; image[24242]=1; image[24243]=1; image[24244]=1; image[24245]=1; image[24246]=1; image[24247]=1; image[24248]=1; image[24249]=1; image[24250]=1; image[24251]=1; image[24252]=1; image[24253]=1; image[24254]=1; image[24255]=1; image[24256]=1; image[24257]=1; image[24258]=1; image[24259]=1; image[24260]=1; image[24261]=1; image[24262]=1; image[24263]=1; image[24264]=1; image[24265]=1; image[24266]=1; image[24267]=1; image[24268]=1; image[24269]=1; image[24270]=1; image[24271]=1; image[24272]=1; image[24273]=1; image[24274]=1; image[24275]=1; image[24276]=1; image[24277]=1; image[24278]=1; image[24279]=1; image[24280]=1; image[24281]=1; image[24282]=1; image[24283]=1; image[24284]=1; image[24285]=1; image[24286]=1; image[24287]=1; image[24288]=1; image[24289]=1; image[24290]=1; image[24291]=1; image[24292]=1; image[24293]=1; image[24294]=1; image[24295]=1; image[24296]=1; image[24297]=1; image[24298]=1; image[24299]=1; image[24300]=1; image[24301]=1; image[24302]=1; image[24303]=1; image[24304]=1; image[24305]=1; image[24306]=1; image[24307]=1; image[24308]=1; image[24309]=1; image[24310]=1; image[24311]=1; image[24312]=1; image[24313]=1; image[24314]=1; image[24315]=1; image[24316]=1; image[24317]=1; image[24318]=1; image[24319]=1; image[24320]=1; image[24321]=1; image[24322]=1; image[24323]=1; image[24324]=1; image[24325]=1; image[24326]=1; image[24327]=1; image[24328]=1; image[24329]=1; image[24330]=1; image[24331]=1; image[24332]=1; image[24333]=1; image[24334]=1; image[24335]=1; image[24336]=1; image[24337]=1; image[24338]=1; image[24339]=1; image[24340]=1; image[24341]=1; image[24342]=1; image[24343]=1; image[24344]=1; image[24345]=1; image[24346]=1; image[24347]=1; image[24348]=1; image[24349]=1; image[24350]=1; image[24351]=1; image[24352]=1; image[24353]=1; image[24354]=1; image[24355]=1; image[24356]=1; image[24357]=1; image[24358]=1; image[24359]=1; image[24360]=2; image[24361]=6; image[24362]=8; image[24363]=8; image[24364]=8; image[24365]=6; image[24366]=3; image[24367]=3; image[24368]=7; image[24369]=9; image[24370]=8; image[24371]=17; image[24372]=27; image[24373]=27; image[24374]=29; image[24375]=29; image[24376]=34; image[24377]=38; image[24378]=32; image[24379]=32; image[24380]=41; image[24381]=39; image[24382]=46; image[24383]=50; image[24384]=51; image[24385]=46; image[24386]=45; image[24387]=55; image[24388]=47; image[24389]=45; image[24390]=22; image[24391]=14; image[24392]=27; image[24393]=38; image[24394]=39; image[24395]=51; image[24396]=77; image[24397]=105; image[24398]=83; image[24399]=91; image[24400]=189; image[24401]=205; image[24402]=167; image[24403]=42; image[24404]=31; image[24405]=111; image[24406]=68; image[24407]=17; image[24408]=30; image[24409]=142; image[24410]=248; image[24411]=255; image[24412]=147; image[24413]=108; image[24414]=164; image[24415]=200; image[24416]=158; image[24417]=220; image[24418]=183; image[24419]=182; image[24420]=219; image[24421]=134; image[24422]=164; image[24423]=198; image[24424]=228; image[24425]=254; image[24426]=241; image[24427]=200; image[24428]=255; image[24429]=245; image[24430]=193; image[24431]=214; image[24432]=55; image[24433]=36; image[24434]=13; image[24435]=3; image[24436]=2; image[24437]=1; image[24438]=1; image[24439]=1; image[24440]=1; image[24441]=1; image[24442]=1; image[24443]=1; image[24444]=1; image[24445]=1; image[24446]=1; image[24447]=1; image[24448]=1; image[24449]=1; image[24450]=1; image[24451]=1; image[24452]=1; image[24453]=1; image[24454]=1; image[24455]=1; image[24456]=1; image[24457]=1; image[24458]=1; image[24459]=1; image[24460]=1; image[24461]=1; image[24462]=1; image[24463]=1; image[24464]=1; image[24465]=1; image[24466]=1; image[24467]=1; image[24468]=1; image[24469]=1; image[24470]=1; image[24471]=1; image[24472]=1; image[24473]=1; image[24474]=1; image[24475]=1; image[24476]=1; image[24477]=1; image[24478]=1; image[24479]=1; image[24480]=1; image[24481]=1; image[24482]=1; image[24483]=1; image[24484]=1; image[24485]=1; image[24486]=1; image[24487]=1; image[24488]=1; image[24489]=1; image[24490]=1; image[24491]=1; image[24492]=1; image[24493]=1; image[24494]=1; image[24495]=1; image[24496]=1; image[24497]=1; image[24498]=1; image[24499]=1; image[24500]=1; image[24501]=1; image[24502]=1; image[24503]=1; image[24504]=1; image[24505]=1; image[24506]=1; image[24507]=1; image[24508]=1; image[24509]=1; image[24510]=1; image[24511]=1; image[24512]=1; image[24513]=1; image[24514]=1; image[24515]=1; image[24516]=1; image[24517]=1; image[24518]=1; image[24519]=1; image[24520]=1; image[24521]=1; image[24522]=1; image[24523]=1; image[24524]=1; image[24525]=1; image[24526]=1; image[24527]=1; image[24528]=1; image[24529]=1; image[24530]=1; image[24531]=1; image[24532]=1; image[24533]=1; image[24534]=1; image[24535]=1; image[24536]=1; image[24537]=1; image[24538]=1; image[24539]=1; image[24540]=1; image[24541]=1; image[24542]=1; image[24543]=1; image[24544]=1; image[24545]=1; image[24546]=1; image[24547]=1; image[24548]=1; image[24549]=1; image[24550]=1; image[24551]=1; image[24552]=1; image[24553]=1; image[24554]=1; image[24555]=1; image[24556]=1; image[24557]=1; image[24558]=1; image[24559]=1; image[24560]=4; image[24561]=6; image[24562]=7; image[24563]=8; image[24564]=6; image[24565]=3; image[24566]=3; image[24567]=7; image[24568]=6; image[24569]=9; image[24570]=18; image[24571]=24; image[24572]=24; image[24573]=28; image[24574]=30; image[24575]=29; image[24576]=41; image[24577]=35; image[24578]=39; image[24579]=39; image[24580]=35; image[24581]=46; image[24582]=50; image[24583]=41; image[24584]=44; image[24585]=45; image[24586]=42; image[24587]=34; image[24588]=38; image[24589]=20; image[24590]=17; image[24591]=28; image[24592]=40; image[24593]=41; image[24594]=52; image[24595]=82; image[24596]=104; image[24597]=87; image[24598]=95; image[24599]=187; image[24600]=215; image[24601]=180; image[24602]=62; image[24603]=33; image[24604]=108; image[24605]=106; image[24606]=45; image[24607]=24; image[24608]=80; image[24609]=213; image[24610]=255; image[24611]=183; image[24612]=127; image[24613]=138; image[24614]=126; image[24615]=150; image[24616]=218; image[24617]=173; image[24618]=139; image[24619]=194; image[24620]=167; image[24621]=152; image[24622]=194; image[24623]=221; image[24624]=249; image[24625]=247; image[24626]=236; image[24627]=255; image[24628]=250; image[24629]=246; image[24630]=224; image[24631]=43; image[24632]=32; image[24633]=11; image[24634]=3; image[24635]=1; image[24636]=1; image[24637]=1; image[24638]=1; image[24639]=1; image[24640]=1; image[24641]=1; image[24642]=1; image[24643]=1; image[24644]=1; image[24645]=1; image[24646]=1; image[24647]=1; image[24648]=1; image[24649]=1; image[24650]=1; image[24651]=1; image[24652]=1; image[24653]=1; image[24654]=1; image[24655]=1; image[24656]=1; image[24657]=1; image[24658]=1; image[24659]=1; image[24660]=1; image[24661]=1; image[24662]=1; image[24663]=1; image[24664]=1; image[24665]=1; image[24666]=1; image[24667]=1; image[24668]=1; image[24669]=1; image[24670]=1; image[24671]=1; image[24672]=1; image[24673]=1; image[24674]=1; image[24675]=1; image[24676]=1; image[24677]=1; image[24678]=1; image[24679]=1; image[24680]=1; image[24681]=1; image[24682]=2; image[24683]=1; image[24684]=1; image[24685]=1; image[24686]=1; image[24687]=1; image[24688]=1; image[24689]=1; image[24690]=1; image[24691]=1; image[24692]=1; image[24693]=1; image[24694]=1; image[24695]=1; image[24696]=1; image[24697]=1; image[24698]=1; image[24699]=1; image[24700]=1; image[24701]=1; image[24702]=1; image[24703]=1; image[24704]=1; image[24705]=1; image[24706]=1; image[24707]=1; image[24708]=1; image[24709]=1; image[24710]=1; image[24711]=1; image[24712]=1; image[24713]=1; image[24714]=1; image[24715]=1; image[24716]=1; image[24717]=1; image[24718]=1; image[24719]=1; image[24720]=1; image[24721]=1; image[24722]=1; image[24723]=1; image[24724]=1; image[24725]=1; image[24726]=1; image[24727]=1; image[24728]=1; image[24729]=1; image[24730]=1; image[24731]=1; image[24732]=1; image[24733]=1; image[24734]=1; image[24735]=1; image[24736]=1; image[24737]=1; image[24738]=1; image[24739]=1; image[24740]=1; image[24741]=1; image[24742]=1; image[24743]=1; image[24744]=1; image[24745]=1; image[24746]=1; image[24747]=1; image[24748]=1; image[24749]=1; image[24750]=1; image[24751]=1; image[24752]=1; image[24753]=1; image[24754]=1; image[24755]=1; image[24756]=1; image[24757]=1; image[24758]=1; image[24759]=3; image[24760]=6; image[24761]=8; image[24762]=8; image[24763]=5; image[24764]=2; image[24765]=3; image[24766]=7; image[24767]=4; image[24768]=10; image[24769]=20; image[24770]=25; image[24771]=25; image[24772]=28; image[24773]=30; image[24774]=28; image[24775]=41; image[24776]=42; image[24777]=45; image[24778]=37; image[24779]=33; image[24780]=38; image[24781]=48; image[24782]=38; image[24783]=42; image[24784]=50; image[24785]=43; image[24786]=28; image[24787]=23; image[24788]=12; image[24789]=18; image[24790]=31; image[24791]=41; image[24792]=40; image[24793]=45; image[24794]=81; image[24795]=104; image[24796]=83; image[24797]=95; image[24798]=179; image[24799]=211; image[24800]=193; image[24801]=100; image[24802]=34; image[24803]=83; image[24804]=125; image[24805]=88; image[24806]=29; image[24807]=47; image[24808]=163; image[24809]=255; image[24810]=222; image[24811]=155; image[24812]=127; image[24813]=112; image[24814]=155; image[24815]=222; image[24816]=199; image[24817]=158; image[24818]=190; image[24819]=220; image[24820]=151; image[24821]=179; image[24822]=203; image[24823]=241; image[24824]=255; image[24825]=255; image[24826]=255; image[24827]=244; image[24828]=249; image[24829]=245; image[24830]=51; image[24831]=41; image[24832]=12; image[24833]=2; image[24834]=1; image[24835]=1; image[24836]=1; image[24837]=1; image[24838]=1; image[24839]=1; image[24840]=1; image[24841]=1; image[24842]=1; image[24843]=1; image[24844]=1; image[24845]=1; image[24846]=1; image[24847]=1; image[24848]=1; image[24849]=1; image[24850]=1; image[24851]=1; image[24852]=1; image[24853]=1; image[24854]=1; image[24855]=1; image[24856]=1; image[24857]=1; image[24858]=1; image[24859]=1; image[24860]=1; image[24861]=1; image[24862]=1; image[24863]=1; image[24864]=1; image[24865]=1; image[24866]=1; image[24867]=1; image[24868]=1; image[24869]=1; image[24870]=1; image[24871]=1; image[24872]=1; image[24873]=1; image[24874]=1; image[24875]=1; image[24876]=1; image[24877]=1; image[24878]=1; image[24879]=1; image[24880]=1; image[24881]=1; image[24882]=1; image[24883]=1; image[24884]=1; image[24885]=1; image[24886]=1; image[24887]=1; image[24888]=1; image[24889]=1; image[24890]=1; image[24891]=1; image[24892]=1; image[24893]=1; image[24894]=1; image[24895]=1; image[24896]=1; image[24897]=1; image[24898]=1; image[24899]=1; image[24900]=1; image[24901]=1; image[24902]=1; image[24903]=1; image[24904]=1; image[24905]=1; image[24906]=1; image[24907]=1; image[24908]=1; image[24909]=1; image[24910]=1; image[24911]=1; image[24912]=1; image[24913]=1; image[24914]=1; image[24915]=1; image[24916]=1; image[24917]=1; image[24918]=1; image[24919]=1; image[24920]=1; image[24921]=1; image[24922]=1; image[24923]=1; image[24924]=1; image[24925]=1; image[24926]=1; image[24927]=1; image[24928]=1; image[24929]=1; image[24930]=1; image[24931]=1; image[24932]=1; image[24933]=1; image[24934]=1; image[24935]=1; image[24936]=1; image[24937]=1; image[24938]=1; image[24939]=1; image[24940]=1; image[24941]=1; image[24942]=1; image[24943]=1; image[24944]=1; image[24945]=1; image[24946]=1; image[24947]=1; image[24948]=1; image[24949]=1; image[24950]=1; image[24951]=1; image[24952]=1; image[24953]=1; image[24954]=1; image[24955]=1; image[24956]=1; image[24957]=1; image[24958]=2; image[24959]=5; image[24960]=7; image[24961]=9; image[24962]=7; image[24963]=3; image[24964]=5; image[24965]=6; image[24966]=5; image[24967]=12; image[24968]=21; image[24969]=25; image[24970]=24; image[24971]=22; image[24972]=27; image[24973]=32; image[24974]=44; image[24975]=49; image[24976]=56; image[24977]=48; image[24978]=41; image[24979]=50; image[24980]=51; image[24981]=49; image[24982]=44; image[24983]=48; image[24984]=57; image[24985]=53; image[24986]=39; image[24987]=16; image[24988]=15; image[24989]=29; image[24990]=35; image[24991]=36; image[24992]=50; image[24993]=74; image[24994]=105; image[24995]=91; image[24996]=91; image[24997]=172; image[24998]=204; image[24999]=172; image[25000]=69; image[25001]=14; image[25002]=64; image[25003]=129; image[25004]=100; image[25005]=61; image[25006]=52; image[25007]=101; image[25008]=217; image[25009]=224; image[25010]=175; image[25011]=170; image[25012]=131; image[25013]=137; image[25014]=148; image[25015]=155; image[25016]=210; image[25017]=168; image[25018]=195; image[25019]=197; image[25020]=176; image[25021]=203; image[25022]=238; image[25023]=255; image[25024]=255; image[25025]=255; image[25026]=251; image[25027]=253; image[25028]=253; image[25029]=37; image[25030]=30; image[25031]=11; image[25032]=1; image[25033]=1; image[25034]=1; image[25035]=1; image[25036]=1; image[25037]=1; image[25038]=1; image[25039]=1; image[25040]=1; image[25041]=1; image[25042]=1; image[25043]=1; image[25044]=1; image[25045]=1; image[25046]=1; image[25047]=1; image[25048]=1; image[25049]=1; image[25050]=1; image[25051]=1; image[25052]=1; image[25053]=1; image[25054]=1; image[25055]=1; image[25056]=1; image[25057]=1; image[25058]=1; image[25059]=1; image[25060]=1; image[25061]=1; image[25062]=1; image[25063]=1; image[25064]=1; image[25065]=1; image[25066]=1; image[25067]=1; image[25068]=1; image[25069]=1; image[25070]=1; image[25071]=1; image[25072]=1; image[25073]=1; image[25074]=1; image[25075]=1; image[25076]=1; image[25077]=1; image[25078]=1; image[25079]=1; image[25080]=1; image[25081]=1; image[25082]=1; image[25083]=1; image[25084]=1; image[25085]=1; image[25086]=1; image[25087]=1; image[25088]=1; image[25089]=1; image[25090]=1; image[25091]=1; image[25092]=1; image[25093]=1; image[25094]=1; image[25095]=1; image[25096]=1; image[25097]=1; image[25098]=1; image[25099]=1; image[25100]=1; image[25101]=1; image[25102]=1; image[25103]=1; image[25104]=1; image[25105]=1; image[25106]=1; image[25107]=1; image[25108]=1; image[25109]=1; image[25110]=1; image[25111]=1; image[25112]=1; image[25113]=1; image[25114]=1; image[25115]=1; image[25116]=1; image[25117]=1; image[25118]=1; image[25119]=1; image[25120]=1; image[25121]=1; image[25122]=1; image[25123]=1; image[25124]=1; image[25125]=1; image[25126]=1; image[25127]=1; image[25128]=1; image[25129]=1; image[25130]=1; image[25131]=1; image[25132]=1; image[25133]=1; image[25134]=1; image[25135]=1; image[25136]=1; image[25137]=1; image[25138]=1; image[25139]=1; image[25140]=1; image[25141]=1; image[25142]=1; image[25143]=1; image[25144]=1; image[25145]=1; image[25146]=1; image[25147]=1; image[25148]=1; image[25149]=1; image[25150]=1; image[25151]=1; image[25152]=1; image[25153]=1; image[25154]=1; image[25155]=1; image[25156]=1; image[25157]=2; image[25158]=5; image[25159]=6; image[25160]=8; image[25161]=7; image[25162]=4; image[25163]=6; image[25164]=6; image[25165]=7; image[25166]=14; image[25167]=17; image[25168]=21; image[25169]=21; image[25170]=20; image[25171]=22; image[25172]=28; image[25173]=39; image[25174]=39; image[25175]=44; image[25176]=44; image[25177]=41; image[25178]=43; image[25179]=44; image[25180]=52; image[25181]=50; image[25182]=44; image[25183]=55; image[25184]=54; image[25185]=41; image[25186]=17; image[25187]=17; image[25188]=30; image[25189]=35; image[25190]=36; image[25191]=53; image[25192]=71; image[25193]=98; image[25194]=93; image[25195]=89; image[25196]=168; image[25197]=206; image[25198]=156; image[25199]=80; image[25200]=19; image[25201]=39; image[25202]=112; image[25203]=106; image[25204]=100; image[25205]=70; image[25206]=94; image[25207]=159; image[25208]=201; image[25209]=174; image[25210]=169; image[25211]=152; image[25212]=146; image[25213]=132; image[25214]=116; image[25215]=183; image[25216]=197; image[25217]=159; image[25218]=194; image[25219]=191; image[25220]=201; image[25221]=230; image[25222]=254; image[25223]=255; image[25224]=255; image[25225]=247; image[25226]=252; image[25227]=235; image[25228]=38; image[25229]=29; image[25230]=9; image[25231]=2; image[25232]=1; image[25233]=1; image[25234]=1; image[25235]=1; image[25236]=1; image[25237]=1; image[25238]=1; image[25239]=1; image[25240]=1; image[25241]=1; image[25242]=1; image[25243]=1; image[25244]=1; image[25245]=1; image[25246]=1; image[25247]=1; image[25248]=1; image[25249]=1; image[25250]=1; image[25251]=1; image[25252]=1; image[25253]=1; image[25254]=1; image[25255]=1; image[25256]=1; image[25257]=1; image[25258]=1; image[25259]=1; image[25260]=1; image[25261]=1; image[25262]=1; image[25263]=1; image[25264]=1; image[25265]=1; image[25266]=1; image[25267]=1; image[25268]=1; image[25269]=1; image[25270]=1; image[25271]=1; image[25272]=1; image[25273]=1; image[25274]=1; image[25275]=1; image[25276]=1; image[25277]=1; image[25278]=1; image[25279]=1; image[25280]=2; image[25281]=1; image[25282]=1; image[25283]=1; image[25284]=1; image[25285]=1; image[25286]=1; image[25287]=1; image[25288]=1; image[25289]=1; image[25290]=1; image[25291]=1; image[25292]=1; image[25293]=1; image[25294]=1; image[25295]=1; image[25296]=1; image[25297]=1; image[25298]=1; image[25299]=1; image[25300]=1; image[25301]=1; image[25302]=1; image[25303]=1; image[25304]=1; image[25305]=1; image[25306]=1; image[25307]=1; image[25308]=1; image[25309]=1; image[25310]=1; image[25311]=1; image[25312]=1; image[25313]=1; image[25314]=1; image[25315]=1; image[25316]=1; image[25317]=1; image[25318]=1; image[25319]=1; image[25320]=1; image[25321]=1; image[25322]=1; image[25323]=1; image[25324]=1; image[25325]=1; image[25326]=1; image[25327]=1; image[25328]=1; image[25329]=1; image[25330]=1; image[25331]=1; image[25332]=1; image[25333]=1; image[25334]=1; image[25335]=1; image[25336]=1; image[25337]=1; image[25338]=1; image[25339]=1; image[25340]=1; image[25341]=1; image[25342]=1; image[25343]=1; image[25344]=1; image[25345]=1; image[25346]=1; image[25347]=1; image[25348]=1; image[25349]=1; image[25350]=1; image[25351]=1; image[25352]=1; image[25353]=1; image[25354]=1; image[25355]=1; image[25356]=2; image[25357]=5; image[25358]=7; image[25359]=8; image[25360]=7; image[25361]=7; image[25362]=6; image[25363]=5; image[25364]=10; image[25365]=14; image[25366]=14; image[25367]=18; image[25368]=17; image[25369]=16; image[25370]=16; image[25371]=21; image[25372]=26; image[25373]=28; image[25374]=32; image[25375]=35; image[25376]=31; image[25377]=31; image[25378]=35; image[25379]=39; image[25380]=48; image[25381]=48; image[25382]=46; image[25383]=39; image[25384]=36; image[25385]=12; image[25386]=21; image[25387]=36; image[25388]=34; image[25389]=33; image[25390]=52; image[25391]=70; image[25392]=91; image[25393]=84; image[25394]=84; image[25395]=173; image[25396]=210; image[25397]=155; image[25398]=88; image[25399]=23; image[25400]=21; image[25401]=110; image[25402]=121; image[25403]=111; image[25404]=82; image[25405]=88; image[25406]=85; image[25407]=146; image[25408]=171; image[25409]=136; image[25410]=166; image[25411]=145; image[25412]=113; image[25413]=114; image[25414]=132; image[25415]=201; image[25416]=176; image[25417]=149; image[25418]=212; image[25419]=197; image[25420]=214; image[25421]=244; image[25422]=255; image[25423]=255; image[25424]=241; image[25425]=244; image[25426]=229; image[25427]=42; image[25428]=24; image[25429]=8; image[25430]=1; image[25431]=1; image[25432]=1; image[25433]=1; image[25434]=1; image[25435]=1; image[25436]=1; image[25437]=1; image[25438]=1; image[25439]=1; image[25440]=1; image[25441]=1; image[25442]=1; image[25443]=1; image[25444]=1; image[25445]=1; image[25446]=1; image[25447]=1; image[25448]=1; image[25449]=1; image[25450]=1; image[25451]=1; image[25452]=1; image[25453]=1; image[25454]=1; image[25455]=1; image[25456]=1; image[25457]=1; image[25458]=1; image[25459]=1; image[25460]=1; image[25461]=1; image[25462]=1; image[25463]=1; image[25464]=1; image[25465]=1; image[25466]=1; image[25467]=1; image[25468]=1; image[25469]=1; image[25470]=1; image[25471]=1; image[25472]=1; image[25473]=1; image[25474]=1; image[25475]=1; image[25476]=1; image[25477]=1; image[25478]=1; image[25479]=1; image[25480]=1; image[25481]=1; image[25482]=1; image[25483]=1; image[25484]=1; image[25485]=1; image[25486]=1; image[25487]=1; image[25488]=1; image[25489]=1; image[25490]=1; image[25491]=1; image[25492]=1; image[25493]=1; image[25494]=1; image[25495]=1; image[25496]=1; image[25497]=1; image[25498]=1; image[25499]=1; image[25500]=1; image[25501]=1; image[25502]=1; image[25503]=1; image[25504]=1; image[25505]=1; image[25506]=1; image[25507]=1; image[25508]=1; image[25509]=1; image[25510]=1; image[25511]=1; image[25512]=1; image[25513]=1; image[25514]=1; image[25515]=1; image[25516]=1; image[25517]=1; image[25518]=1; image[25519]=1; image[25520]=1; image[25521]=1; image[25522]=1; image[25523]=1; image[25524]=1; image[25525]=1; image[25526]=1; image[25527]=1; image[25528]=1; image[25529]=1; image[25530]=1; image[25531]=1; image[25532]=1; image[25533]=1; image[25534]=1; image[25535]=1; image[25536]=1; image[25537]=1; image[25538]=1; image[25539]=1; image[25540]=1; image[25541]=1; image[25542]=1; image[25543]=1; image[25544]=1; image[25545]=1; image[25546]=1; image[25547]=1; image[25548]=1; image[25549]=1; image[25550]=1; image[25551]=1; image[25552]=1; image[25553]=1; image[25554]=1; image[25555]=2; image[25556]=5; image[25557]=6; image[25558]=8; image[25559]=6; image[25560]=6; image[25561]=4; image[25562]=6; image[25563]=8; image[25564]=10; image[25565]=12; image[25566]=14; image[25567]=13; image[25568]=14; image[25569]=14; image[25570]=15; image[25571]=17; image[25572]=20; image[25573]=23; image[25574]=24; image[25575]=26; image[25576]=23; image[25577]=23; image[25578]=27; image[25579]=34; image[25580]=35; image[25581]=26; image[25582]=28; image[25583]=32; image[25584]=8; image[25585]=19; image[25586]=35; image[25587]=28; image[25588]=29; image[25589]=53; image[25590]=68; image[25591]=86; image[25592]=85; image[25593]=84; image[25594]=158; image[25595]=187; image[25596]=143; image[25597]=55; image[25598]=9; image[25599]=10; image[25600]=84; image[25601]=123; image[25602]=93; image[25603]=96; image[25604]=97; image[25605]=116; image[25606]=128; image[25607]=143; image[25608]=137; image[25609]=154; image[25610]=130; image[25611]=137; image[25612]=126; image[25613]=142; image[25614]=131; image[25615]=157; image[25616]=132; image[25617]=192; image[25618]=192; image[25619]=216; image[25620]=252; image[25621]=255; image[25622]=255; image[25623]=236; image[25624]=227; image[25625]=196; image[25626]=21; image[25627]=24; image[25628]=7; image[25629]=1; image[25630]=1; image[25631]=1; image[25632]=1; image[25633]=1; image[25634]=1; image[25635]=1; image[25636]=1; image[25637]=1; image[25638]=1; image[25639]=1; image[25640]=1; image[25641]=1; image[25642]=1; image[25643]=1; image[25644]=1; image[25645]=1; image[25646]=1; image[25647]=1; image[25648]=1; image[25649]=1; image[25650]=1; image[25651]=1; image[25652]=1; image[25653]=1; image[25654]=1; image[25655]=1; image[25656]=1; image[25657]=1; image[25658]=1; image[25659]=1; image[25660]=1; image[25661]=1; image[25662]=1; image[25663]=1; image[25664]=1; image[25665]=1; image[25666]=1; image[25667]=1; image[25668]=1; image[25669]=1; image[25670]=1; image[25671]=1; image[25672]=1; image[25673]=1; image[25674]=1; image[25675]=1; image[25676]=1; image[25677]=1; image[25678]=1; image[25679]=1; image[25680]=1; image[25681]=1; image[25682]=1; image[25683]=1; image[25684]=1; image[25685]=1; image[25686]=1; image[25687]=1; image[25688]=1; image[25689]=1; image[25690]=1; image[25691]=1; image[25692]=1; image[25693]=1; image[25694]=1; image[25695]=1; image[25696]=1; image[25697]=1; image[25698]=1; image[25699]=1; image[25700]=1; image[25701]=1; image[25702]=1; image[25703]=1; image[25704]=1; image[25705]=1; image[25706]=1; image[25707]=1; image[25708]=1; image[25709]=1; image[25710]=1; image[25711]=1; image[25712]=1; image[25713]=1; image[25714]=1; image[25715]=1; image[25716]=1; image[25717]=1; image[25718]=1; image[25719]=1; image[25720]=1; image[25721]=1; image[25722]=1; image[25723]=1; image[25724]=1; image[25725]=1; image[25726]=1; image[25727]=1; image[25728]=1; image[25729]=1; image[25730]=1; image[25731]=1; image[25732]=1; image[25733]=1; image[25734]=1; image[25735]=1; image[25736]=1; image[25737]=1; image[25738]=1; image[25739]=1; image[25740]=1; image[25741]=1; image[25742]=1; image[25743]=1; image[25744]=1; image[25745]=1; image[25746]=1; image[25747]=1; image[25748]=1; image[25749]=1; image[25750]=1; image[25751]=1; image[25752]=1; image[25753]=1; image[25754]=2; image[25755]=5; image[25756]=6; image[25757]=8; image[25758]=5; image[25759]=3; image[25760]=2; image[25761]=4; image[25762]=5; image[25763]=8; image[25764]=8; image[25765]=10; image[25766]=9; image[25767]=12; image[25768]=10; image[25769]=11; image[25770]=10; image[25771]=12; image[25772]=17; image[25773]=19; image[25774]=22; image[25775]=18; image[25776]=17; image[25777]=20; image[25778]=21; image[25779]=17; image[25780]=14; image[25781]=25; image[25782]=29; image[25783]=7; image[25784]=16; image[25785]=31; image[25786]=28; image[25787]=28; image[25788]=54; image[25789]=64; image[25790]=75; image[25791]=77; image[25792]=70; image[25793]=143; image[25794]=186; image[25795]=154; image[25796]=78; image[25797]=12; image[25798]=4; image[25799]=59; image[25800]=122; image[25801]=84; image[25802]=100; image[25803]=100; image[25804]=121; image[25805]=117; image[25806]=105; image[25807]=129; image[25808]=150; image[25809]=135; image[25810]=165; image[25811]=151; image[25812]=139; image[25813]=102; image[25814]=110; image[25815]=147; image[25816]=177; image[25817]=188; image[25818]=214; image[25819]=255; image[25820]=255; image[25821]=255; image[25822]=235; image[25823]=241; image[25824]=203; image[25825]=25; image[25826]=33; image[25827]=8; image[25828]=1; image[25829]=1; image[25830]=1; image[25831]=1; image[25832]=1; image[25833]=1; image[25834]=1; image[25835]=1; image[25836]=1; image[25837]=1; image[25838]=1; image[25839]=1; image[25840]=1; image[25841]=1; image[25842]=1; image[25843]=1; image[25844]=1; image[25845]=1; image[25846]=1; image[25847]=1; image[25848]=1; image[25849]=1; image[25850]=1; image[25851]=1; image[25852]=1; image[25853]=1; image[25854]=1; image[25855]=1; image[25856]=1; image[25857]=1; image[25858]=1; image[25859]=1; image[25860]=1; image[25861]=1; image[25862]=1; image[25863]=1; image[25864]=1; image[25865]=1; image[25866]=1; image[25867]=1; image[25868]=1; image[25869]=1; image[25870]=1; image[25871]=1; image[25872]=1; image[25873]=1; image[25874]=1; image[25875]=1; image[25876]=1; image[25877]=1; image[25878]=1; image[25879]=1; image[25880]=1; image[25881]=1; image[25882]=1; image[25883]=1; image[25884]=1; image[25885]=1; image[25886]=1; image[25887]=1; image[25888]=1; image[25889]=1; image[25890]=1; image[25891]=1; image[25892]=1; image[25893]=1; image[25894]=1; image[25895]=1; image[25896]=1; image[25897]=1; image[25898]=2; image[25899]=1; image[25900]=1; image[25901]=1; image[25902]=1; image[25903]=1; image[25904]=1; image[25905]=1; image[25906]=1; image[25907]=1; image[25908]=1; image[25909]=1; image[25910]=1; image[25911]=1; image[25912]=1; image[25913]=1; image[25914]=1; image[25915]=1; image[25916]=1; image[25917]=1; image[25918]=1; image[25919]=1; image[25920]=1; image[25921]=1; image[25922]=1; image[25923]=1; image[25924]=1; image[25925]=1; image[25926]=1; image[25927]=1; image[25928]=1; image[25929]=1; image[25930]=1; image[25931]=1; image[25932]=1; image[25933]=1; image[25934]=1; image[25935]=1; image[25936]=1; image[25937]=1; image[25938]=1; image[25939]=1; image[25940]=1; image[25941]=1; image[25942]=1; image[25943]=1; image[25944]=1; image[25945]=1; image[25946]=1; image[25947]=1; image[25948]=1; image[25949]=1; image[25950]=1; image[25951]=1; image[25952]=1; image[25953]=1; image[25954]=4; image[25955]=6; image[25956]=7; image[25957]=6; image[25958]=4; image[25959]=2; image[25960]=3; image[25961]=4; image[25962]=3; image[25963]=4; image[25964]=9; image[25965]=9; image[25966]=8; image[25967]=7; image[25968]=7; image[25969]=9; image[25970]=14; image[25971]=16; image[25972]=16; image[25973]=13; image[25974]=13; image[25975]=16; image[25976]=10; image[25977]=8; image[25978]=8; image[25979]=11; image[25980]=26; image[25981]=25; image[25982]=5; image[25983]=15; image[25984]=30; image[25985]=31; image[25986]=27; image[25987]=49; image[25988]=57; image[25989]=71; image[25990]=72; image[25991]=61; image[25992]=140; image[25993]=195; image[25994]=170; image[25995]=72; image[25996]=6; image[25997]=1; image[25998]=12; image[25999]=103; image[26000]=105; image[26001]=77; image[26002]=88; image[26003]=114; image[26004]=104; image[26005]=78; image[26006]=110; image[26007]=136; image[26008]=131; image[26009]=185; image[26010]=222; image[26011]=169; image[26012]=106; image[26013]=63; image[26014]=190; image[26015]=188; image[26016]=179; image[26017]=218; image[26018]=255; image[26019]=255; image[26020]=255; image[26021]=227; image[26022]=232; image[26023]=221; image[26024]=31; image[26025]=30; image[26026]=8; image[26027]=2; image[26028]=1; image[26029]=1; image[26030]=1; image[26031]=1; image[26032]=1; image[26033]=1; image[26034]=1; image[26035]=1; image[26036]=1; image[26037]=1; image[26038]=1; image[26039]=1; image[26040]=1; image[26041]=1; image[26042]=1; image[26043]=1; image[26044]=1; image[26045]=1; image[26046]=1; image[26047]=1; image[26048]=1; image[26049]=1; image[26050]=1; image[26051]=1; image[26052]=1; image[26053]=1; image[26054]=1; image[26055]=1; image[26056]=1; image[26057]=1; image[26058]=1; image[26059]=1; image[26060]=1; image[26061]=1; image[26062]=1; image[26063]=1; image[26064]=1; image[26065]=1; image[26066]=1; image[26067]=1; image[26068]=1; image[26069]=1; image[26070]=1; image[26071]=1; image[26072]=1; image[26073]=1; image[26074]=1; image[26075]=1; image[26076]=1; image[26077]=1; image[26078]=1; image[26079]=1; image[26080]=1; image[26081]=1; image[26082]=1; image[26083]=1; image[26084]=1; image[26085]=1; image[26086]=1; image[26087]=1; image[26088]=1; image[26089]=1; image[26090]=1; image[26091]=1; image[26092]=1; image[26093]=1; image[26094]=1; image[26095]=1; image[26096]=1; image[26097]=1; image[26098]=1; image[26099]=1; image[26100]=1; image[26101]=1; image[26102]=1; image[26103]=1; image[26104]=1; image[26105]=1; image[26106]=1; image[26107]=1; image[26108]=1; image[26109]=1; image[26110]=1; image[26111]=1; image[26112]=1; image[26113]=1; image[26114]=1; image[26115]=1; image[26116]=1; image[26117]=1; image[26118]=1; image[26119]=1; image[26120]=1; image[26121]=1; image[26122]=1; image[26123]=1; image[26124]=1; image[26125]=1; image[26126]=1; image[26127]=1; image[26128]=1; image[26129]=1; image[26130]=1; image[26131]=1; image[26132]=1; image[26133]=1; image[26134]=1; image[26135]=1; image[26136]=1; image[26137]=1; image[26138]=1; image[26139]=1; image[26140]=1; image[26141]=1; image[26142]=1; image[26143]=1; image[26144]=1; image[26145]=1; image[26146]=1; image[26147]=1; image[26148]=1; image[26149]=1; image[26150]=1; image[26151]=1; image[26152]=2; image[26153]=5; image[26154]=7; image[26155]=6; image[26156]=6; image[26157]=5; image[26158]=3; image[26159]=4; image[26160]=4; image[26161]=5; image[26162]=6; image[26163]=7; image[26164]=7; image[26165]=5; image[26166]=5; image[26167]=6; image[26168]=7; image[26169]=7; image[26170]=9; image[26171]=9; image[26172]=8; image[26173]=7; image[26174]=8; image[26175]=6; image[26176]=6; image[26177]=6; image[26178]=7; image[26179]=17; image[26180]=18; image[26181]=5; image[26182]=20; image[26183]=30; image[26184]=31; image[26185]=29; image[26186]=49; image[26187]=52; image[26188]=70; image[26189]=71; image[26190]=63; image[26191]=154; image[26192]=227; image[26193]=192; image[26194]=73; image[26195]=7; image[26196]=2; image[26197]=3; image[26198]=57; image[26199]=107; image[26200]=63; image[26201]=102; image[26202]=176; image[26203]=104; image[26204]=78; image[26205]=105; image[26206]=129; image[26207]=135; image[26208]=183; image[26209]=203; image[26210]=163; image[26211]=119; image[26212]=77; image[26213]=208; image[26214]=230; image[26215]=189; image[26216]=233; image[26217]=255; image[26218]=255; image[26219]=255; image[26220]=234; image[26221]=195; image[26222]=172; image[26223]=29; image[26224]=33; image[26225]=9; image[26226]=2; image[26227]=1; image[26228]=1; image[26229]=1; image[26230]=1; image[26231]=1; image[26232]=1; image[26233]=1; image[26234]=0; image[26235]=1; image[26236]=1; image[26237]=1; image[26238]=1; image[26239]=1; image[26240]=1; image[26241]=1; image[26242]=1; image[26243]=1; image[26244]=1; image[26245]=1; image[26246]=1; image[26247]=1; image[26248]=1; image[26249]=1; image[26250]=1; image[26251]=1; image[26252]=1; image[26253]=1; image[26254]=1; image[26255]=1; image[26256]=1; image[26257]=1; image[26258]=1; image[26259]=1; image[26260]=1; image[26261]=1; image[26262]=1; image[26263]=1; image[26264]=1; image[26265]=1; image[26266]=1; image[26267]=1; image[26268]=1; image[26269]=1; image[26270]=1; image[26271]=1; image[26272]=1; image[26273]=1; image[26274]=1; image[26275]=1; image[26276]=1; image[26277]=1; image[26278]=1; image[26279]=1; image[26280]=1; image[26281]=1; image[26282]=1; image[26283]=1; image[26284]=1; image[26285]=1; image[26286]=1; image[26287]=1; image[26288]=1; image[26289]=1; image[26290]=1; image[26291]=1; image[26292]=1; image[26293]=1; image[26294]=1; image[26295]=1; image[26296]=1; image[26297]=1; image[26298]=1; image[26299]=1; image[26300]=1; image[26301]=1; image[26302]=1; image[26303]=1; image[26304]=1; image[26305]=1; image[26306]=1; image[26307]=1; image[26308]=1; image[26309]=1; image[26310]=1; image[26311]=1; image[26312]=1; image[26313]=1; image[26314]=1; image[26315]=1; image[26316]=1; image[26317]=1; image[26318]=1; image[26319]=1; image[26320]=1; image[26321]=1; image[26322]=1; image[26323]=1; image[26324]=1; image[26325]=1; image[26326]=1; image[26327]=1; image[26328]=1; image[26329]=1; image[26330]=1; image[26331]=1; image[26332]=1; image[26333]=1; image[26334]=1; image[26335]=1; image[26336]=1; image[26337]=1; image[26338]=1; image[26339]=1; image[26340]=1; image[26341]=1; image[26342]=1; image[26343]=1; image[26344]=1; image[26345]=1; image[26346]=1; image[26347]=1; image[26348]=1; image[26349]=1; image[26350]=1; image[26351]=3; image[26352]=6; image[26353]=8; image[26354]=7; image[26355]=6; image[26356]=5; image[26357]=5; image[26358]=10; image[26359]=13; image[26360]=14; image[26361]=17; image[26362]=23; image[26363]=22; image[26364]=21; image[26365]=20; image[26366]=19; image[26367]=23; image[26368]=19; image[26369]=20; image[26370]=22; image[26371]=20; image[26372]=21; image[26373]=15; image[26374]=8; image[26375]=8; image[26376]=6; image[26377]=6; image[26378]=6; image[26379]=7; image[26380]=7; image[26381]=23; image[26382]=31; image[26383]=33; image[26384]=31; image[26385]=59; image[26386]=58; image[26387]=68; image[26388]=76; image[26389]=65; image[26390]=159; image[26391]=241; image[26392]=193; image[26393]=65; image[26394]=7; image[26395]=4; image[26396]=5; image[26397]=29; image[26398]=95; image[26399]=67; image[26400]=102; image[26401]=164; image[26402]=114; image[26403]=87; image[26404]=95; image[26405]=122; image[26406]=136; image[26407]=151; image[26408]=134; image[26409]=142; image[26410]=129; image[26411]=102; image[26412]=190; image[26413]=253; image[26414]=240; image[26415]=238; image[26416]=255; image[26417]=255; image[26418]=255; image[26419]=242; image[26420]=201; image[26421]=137; image[26422]=23; image[26423]=31; image[26424]=8; image[26425]=2; image[26426]=1; image[26427]=1; image[26428]=1; image[26429]=1; image[26430]=1; image[26431]=1; image[26432]=1; image[26433]=1; image[26434]=1; image[26435]=1; image[26436]=1; image[26437]=1; image[26438]=1; image[26439]=1; image[26440]=1; image[26441]=1; image[26442]=1; image[26443]=1; image[26444]=1; image[26445]=1; image[26446]=1; image[26447]=1; image[26448]=1; image[26449]=1; image[26450]=1; image[26451]=1; image[26452]=1; image[26453]=1; image[26454]=1; image[26455]=1; image[26456]=1; image[26457]=1; image[26458]=1; image[26459]=1; image[26460]=1; image[26461]=1; image[26462]=1; image[26463]=1; image[26464]=1; image[26465]=1; image[26466]=1; image[26467]=1; image[26468]=1; image[26469]=1; image[26470]=1; image[26471]=1; image[26472]=1; image[26473]=1; image[26474]=1; image[26475]=1; image[26476]=1; image[26477]=1; image[26478]=1; image[26479]=1; image[26480]=1; image[26481]=1; image[26482]=1; image[26483]=1; image[26484]=1; image[26485]=1; image[26486]=1; image[26487]=1; image[26488]=1; image[26489]=1; image[26490]=1; image[26491]=1; image[26492]=1; image[26493]=1; image[26494]=1; image[26495]=1; image[26496]=1; image[26497]=1; image[26498]=1; image[26499]=1; image[26500]=1; image[26501]=1; image[26502]=1; image[26503]=1; image[26504]=1; image[26505]=1; image[26506]=1; image[26507]=1; image[26508]=1; image[26509]=1; image[26510]=1; image[26511]=1; image[26512]=1; image[26513]=1; image[26514]=1; image[26515]=1; image[26516]=0; image[26517]=1; image[26518]=1; image[26519]=1; image[26520]=1; image[26521]=1; image[26522]=1; image[26523]=1; image[26524]=1; image[26525]=1; image[26526]=1; image[26527]=1; image[26528]=1; image[26529]=1; image[26530]=1; image[26531]=1; image[26532]=1; image[26533]=1; image[26534]=1; image[26535]=1; image[26536]=1; image[26537]=1; image[26538]=1; image[26539]=1; image[26540]=1; image[26541]=1; image[26542]=1; image[26543]=1; image[26544]=1; image[26545]=1; image[26546]=1; image[26547]=1; image[26548]=1; image[26549]=1; image[26550]=3; image[26551]=6; image[26552]=9; image[26553]=8; image[26554]=6; image[26555]=5; image[26556]=4; image[26557]=6; image[26558]=8; image[26559]=12; image[26560]=17; image[26561]=24; image[26562]=25; image[26563]=25; image[26564]=28; image[26565]=25; image[26566]=33; image[26567]=46; image[26568]=51; image[26569]=54; image[26570]=52; image[26571]=42; image[26572]=37; image[26573]=39; image[26574]=45; image[26575]=45; image[26576]=29; image[26577]=17; image[26578]=9; image[26579]=9; image[26580]=29; image[26581]=33; image[26582]=31; image[26583]=32; image[26584]=58; image[26585]=61; image[26586]=61; image[26587]=75; image[26588]=65; image[26589]=121; image[26590]=164; image[26591]=134; image[26592]=46; image[26593]=8; image[26594]=5; image[26595]=11; image[26596]=21; image[26597]=62; image[26598]=69; image[26599]=85; image[26600]=93; image[26601]=103; image[26602]=103; image[26603]=96; image[26604]=115; image[26605]=122; image[26606]=109; image[26607]=98; image[26608]=135; image[26609]=133; image[26610]=136; image[26611]=158; image[26612]=230; image[26613]=241; image[26614]=195; image[26615]=250; image[26616]=255; image[26617]=255; image[26618]=250; image[26619]=245; image[26620]=143; image[26621]=27; image[26622]=30; image[26623]=7; image[26624]=2; image[26625]=1; image[26626]=1; image[26627]=1; image[26628]=1; image[26629]=1; image[26630]=1; image[26631]=1; image[26632]=1; image[26633]=1; image[26634]=1; image[26635]=1; image[26636]=1; image[26637]=1; image[26638]=1; image[26639]=1; image[26640]=1; image[26641]=1; image[26642]=1; image[26643]=1; image[26644]=1; image[26645]=1; image[26646]=1; image[26647]=1; image[26648]=1; image[26649]=1; image[26650]=1; image[26651]=1; image[26652]=1; image[26653]=1; image[26654]=1; image[26655]=1; image[26656]=1; image[26657]=1; image[26658]=1; image[26659]=1; image[26660]=1; image[26661]=1; image[26662]=1; image[26663]=1; image[26664]=1; image[26665]=1; image[26666]=1; image[26667]=1; image[26668]=1; image[26669]=1; image[26670]=1; image[26671]=1; image[26672]=1; image[26673]=1; image[26674]=1; image[26675]=1; image[26676]=1; image[26677]=1; image[26678]=1; image[26679]=1; image[26680]=1; image[26681]=1; image[26682]=1; image[26683]=1; image[26684]=1; image[26685]=1; image[26686]=1; image[26687]=1; image[26688]=1; image[26689]=1; image[26690]=1; image[26691]=1; image[26692]=1; image[26693]=1; image[26694]=1; image[26695]=1; image[26696]=1; image[26697]=1; image[26698]=1; image[26699]=1; image[26700]=1; image[26701]=1; image[26702]=1; image[26703]=1; image[26704]=1; image[26705]=1; image[26706]=1; image[26707]=1; image[26708]=1; image[26709]=1; image[26710]=1; image[26711]=1; image[26712]=1; image[26713]=1; image[26714]=1; image[26715]=1; image[26716]=1; image[26717]=1; image[26718]=1; image[26719]=1; image[26720]=1; image[26721]=1; image[26722]=1; image[26723]=1; image[26724]=1; image[26725]=1; image[26726]=1; image[26727]=1; image[26728]=1; image[26729]=1; image[26730]=1; image[26731]=1; image[26732]=1; image[26733]=1; image[26734]=1; image[26735]=1; image[26736]=1; image[26737]=1; image[26738]=1; image[26739]=1; image[26740]=1; image[26741]=1; image[26742]=1; image[26743]=1; image[26744]=1; image[26745]=1; image[26746]=1; image[26747]=1; image[26748]=1; image[26749]=3; image[26750]=6; image[26751]=11; image[26752]=9; image[26753]=6; image[26754]=5; image[26755]=3; image[26756]=3; image[26757]=4; image[26758]=6; image[26759]=8; image[26760]=14; image[26761]=22; image[26762]=24; image[26763]=25; image[26764]=29; image[26765]=30; image[26766]=26; image[26767]=29; image[26768]=33; image[26769]=47; image[26770]=48; image[26771]=40; image[26772]=41; image[26773]=37; image[26774]=29; image[26775]=17; image[26776]=9; image[26777]=4; image[26778]=5; image[26779]=22; image[26780]=35; image[26781]=31; image[26782]=32; image[26783]=54; image[26784]=64; image[26785]=62; image[26786]=74; image[26787]=57; image[26788]=93; image[26789]=131; image[26790]=108; image[26791]=39; image[26792]=8; image[26793]=10; image[26794]=27; image[26795]=33; image[26796]=55; image[26797]=54; image[26798]=65; image[26799]=59; image[26800]=80; image[26801]=102; image[26802]=99; image[26803]=113; image[26804]=110; image[26805]=87; image[26806]=99; image[26807]=122; image[26808]=144; image[26809]=162; image[26810]=150; image[26811]=218; image[26812]=242; image[26813]=185; image[26814]=221; image[26815]=254; image[26816]=255; image[26817]=236; image[26818]=243; image[26819]=152; image[26820]=25; image[26821]=32; image[26822]=7; image[26823]=2; image[26824]=1; image[26825]=1; image[26826]=1; image[26827]=1; image[26828]=1; image[26829]=1; image[26830]=1; image[26831]=1; image[26832]=1; image[26833]=1; image[26834]=1; image[26835]=1; image[26836]=1; image[26837]=1; image[26838]=1; image[26839]=1; image[26840]=1; image[26841]=1; image[26842]=1; image[26843]=1; image[26844]=1; image[26845]=1; image[26846]=1; image[26847]=1; image[26848]=1; image[26849]=1; image[26850]=1; image[26851]=1; image[26852]=1; image[26853]=1; image[26854]=1; image[26855]=1; image[26856]=1; image[26857]=1; image[26858]=1; image[26859]=1; image[26860]=1; image[26861]=1; image[26862]=1; image[26863]=1; image[26864]=1; image[26865]=1; image[26866]=1; image[26867]=1; image[26868]=1; image[26869]=1; image[26870]=1; image[26871]=1; image[26872]=1; image[26873]=1; image[26874]=1; image[26875]=1; image[26876]=1; image[26877]=1; image[26878]=1; image[26879]=1; image[26880]=1; image[26881]=1; image[26882]=1; image[26883]=1; image[26884]=1; image[26885]=1; image[26886]=1; image[26887]=1; image[26888]=1; image[26889]=1; image[26890]=1; image[26891]=1; image[26892]=1; image[26893]=1; image[26894]=1; image[26895]=1; image[26896]=1; image[26897]=1; image[26898]=1; image[26899]=1; image[26900]=1; image[26901]=1; image[26902]=1; image[26903]=1; image[26904]=1; image[26905]=1; image[26906]=1; image[26907]=1; image[26908]=1; image[26909]=1; image[26910]=1; image[26911]=1; image[26912]=1; image[26913]=1; image[26914]=1; image[26915]=1; image[26916]=1; image[26917]=1; image[26918]=1; image[26919]=1; image[26920]=1; image[26921]=1; image[26922]=1; image[26923]=1; image[26924]=1; image[26925]=1; image[26926]=1; image[26927]=1; image[26928]=1; image[26929]=1; image[26930]=1; image[26931]=1; image[26932]=1; image[26933]=1; image[26934]=1; image[26935]=1; image[26936]=1; image[26937]=1; image[26938]=1; image[26939]=1; image[26940]=1; image[26941]=1; image[26942]=1; image[26943]=1; image[26944]=1; image[26945]=1; image[26946]=1; image[26947]=1; image[26948]=3; image[26949]=6; image[26950]=8; image[26951]=8; image[26952]=7; image[26953]=5; image[26954]=5; image[26955]=6; image[26956]=7; image[26957]=6; image[26958]=4; image[26959]=8; image[26960]=11; image[26961]=14; image[26962]=10; image[26963]=14; image[26964]=19; image[26965]=12; image[26966]=10; image[26967]=11; image[26968]=16; image[26969]=28; image[26970]=25; image[26971]=20; image[26972]=12; image[26973]=10; image[26974]=7; image[26975]=8; image[26976]=7; image[26977]=6; image[26978]=17; image[26979]=30; image[26980]=30; image[26981]=33; image[26982]=52; image[26983]=62; image[26984]=60; image[26985]=76; image[26986]=61; image[26987]=102; image[26988]=100; image[26989]=90; image[26990]=39; image[26991]=9; image[26992]=17; image[26993]=64; image[26994]=78; image[26995]=57; image[26996]=61; image[26997]=65; image[26998]=71; image[26999]=85; image[27000]=97; image[27001]=112; image[27002]=127; image[27003]=123; image[27004]=90; image[27005]=101; image[27006]=124; image[27007]=144; image[27008]=150; image[27009]=132; image[27010]=213; image[27011]=245; image[27012]=175; image[27013]=206; image[27014]=253; image[27015]=255; image[27016]=231; image[27017]=246; image[27018]=179; image[27019]=21; image[27020]=31; image[27021]=8; image[27022]=1; image[27023]=1; image[27024]=1; image[27025]=1; image[27026]=1; image[27027]=1; image[27028]=1; image[27029]=1; image[27030]=1; image[27031]=1; image[27032]=1; image[27033]=1; image[27034]=1; image[27035]=1; image[27036]=1; image[27037]=1; image[27038]=1; image[27039]=1; image[27040]=1; image[27041]=1; image[27042]=1; image[27043]=1; image[27044]=1; image[27045]=1; image[27046]=1; image[27047]=1; image[27048]=1; image[27049]=1; image[27050]=1; image[27051]=1; image[27052]=1; image[27053]=1; image[27054]=1; image[27055]=1; image[27056]=1; image[27057]=1; image[27058]=1; image[27059]=1; image[27060]=1; image[27061]=1; image[27062]=1; image[27063]=1; image[27064]=1; image[27065]=1; image[27066]=1; image[27067]=1; image[27068]=1; image[27069]=1; image[27070]=1; image[27071]=1; image[27072]=1; image[27073]=1; image[27074]=1; image[27075]=1; image[27076]=1; image[27077]=1; image[27078]=1; image[27079]=1; image[27080]=1; image[27081]=1; image[27082]=1; image[27083]=1; image[27084]=1; image[27085]=1; image[27086]=1; image[27087]=1; image[27088]=1; image[27089]=1; image[27090]=1; image[27091]=1; image[27092]=1; image[27093]=1; image[27094]=1; image[27095]=1; image[27096]=1; image[27097]=1; image[27098]=1; image[27099]=1; image[27100]=1; image[27101]=1; image[27102]=1; image[27103]=1; image[27104]=1; image[27105]=1; image[27106]=1; image[27107]=1; image[27108]=1; image[27109]=1; image[27110]=1; image[27111]=1; image[27112]=1; image[27113]=1; image[27114]=1; image[27115]=1; image[27116]=1; image[27117]=1; image[27118]=1; image[27119]=1; image[27120]=1; image[27121]=1; image[27122]=1; image[27123]=1; image[27124]=1; image[27125]=1; image[27126]=1; image[27127]=1; image[27128]=1; image[27129]=1; image[27130]=1; image[27131]=1; image[27132]=1; image[27133]=1; image[27134]=1; image[27135]=1; image[27136]=1; image[27137]=1; image[27138]=1; image[27139]=1; image[27140]=1; image[27141]=1; image[27142]=1; image[27143]=1; image[27144]=1; image[27145]=1; image[27146]=2; image[27147]=4; image[27148]=7; image[27149]=8; image[27150]=8; image[27151]=7; image[27152]=6; image[27153]=9; image[27154]=11; image[27155]=13; image[27156]=12; image[27157]=11; image[27158]=12; image[27159]=11; image[27160]=12; image[27161]=10; image[27162]=7; image[27163]=9; image[27164]=12; image[27165]=14; image[27166]=15; image[27167]=13; image[27168]=12; image[27169]=12; image[27170]=13; image[27171]=15; image[27172]=18; image[27173]=16; image[27174]=33; image[27175]=28; image[27176]=8; image[27177]=18; image[27178]=32; image[27179]=28; image[27180]=32; image[27181]=56; image[27182]=69; image[27183]=65; image[27184]=78; image[27185]=63; image[27186]=128; image[27187]=93; image[27188]=59; image[27189]=26; image[27190]=9; image[27191]=16; image[27192]=97; image[27193]=149; image[27194]=46; image[27195]=68; image[27196]=70; image[27197]=102; image[27198]=96; image[27199]=94; image[27200]=114; image[27201]=116; image[27202]=99; image[27203]=100; image[27204]=96; image[27205]=106; image[27206]=121; image[27207]=147; image[27208]=129; image[27209]=217; image[27210]=244; image[27211]=169; image[27212]=200; image[27213]=253; image[27214]=255; image[27215]=240; image[27216]=219; image[27217]=139; image[27218]=16; image[27219]=26; image[27220]=7; image[27221]=1; image[27222]=1; image[27223]=1; image[27224]=1; image[27225]=1; image[27226]=1; image[27227]=1; image[27228]=1; image[27229]=1; image[27230]=1; image[27231]=1; image[27232]=1; image[27233]=1; image[27234]=1; image[27235]=1; image[27236]=1; image[27237]=1; image[27238]=1; image[27239]=1; image[27240]=1; image[27241]=1; image[27242]=1; image[27243]=1; image[27244]=1; image[27245]=1; image[27246]=1; image[27247]=1; image[27248]=1; image[27249]=1; image[27250]=1; image[27251]=1; image[27252]=1; image[27253]=1; image[27254]=1; image[27255]=1; image[27256]=1; image[27257]=1; image[27258]=1; image[27259]=1; image[27260]=1; image[27261]=1; image[27262]=1; image[27263]=1; image[27264]=1; image[27265]=1; image[27266]=1; image[27267]=1; image[27268]=1; image[27269]=1; image[27270]=1; image[27271]=1; image[27272]=1; image[27273]=1; image[27274]=1; image[27275]=1; image[27276]=1; image[27277]=1; image[27278]=1; image[27279]=1; image[27280]=1; image[27281]=1; image[27282]=1; image[27283]=1; image[27284]=1; image[27285]=1; image[27286]=1; image[27287]=1; image[27288]=1; image[27289]=1; image[27290]=1; image[27291]=1; image[27292]=1; image[27293]=1; image[27294]=1; image[27295]=1; image[27296]=1; image[27297]=1; image[27298]=1; image[27299]=1; image[27300]=1; image[27301]=1; image[27302]=1; image[27303]=1; image[27304]=1; image[27305]=1; image[27306]=1; image[27307]=1; image[27308]=1; image[27309]=1; image[27310]=1; image[27311]=1; image[27312]=1; image[27313]=1; image[27314]=1; image[27315]=1; image[27316]=1; image[27317]=1; image[27318]=1; image[27319]=1; image[27320]=1; image[27321]=1; image[27322]=1; image[27323]=1; image[27324]=1; image[27325]=1; image[27326]=1; image[27327]=1; image[27328]=1; image[27329]=1; image[27330]=1; image[27331]=1; image[27332]=1; image[27333]=1; image[27334]=1; image[27335]=1; image[27336]=1; image[27337]=1; image[27338]=1; image[27339]=1; image[27340]=1; image[27341]=1; image[27342]=1; image[27343]=1; image[27344]=1; image[27345]=2; image[27346]=5; image[27347]=7; image[27348]=9; image[27349]=9; image[27350]=9; image[27351]=6; image[27352]=5; image[27353]=8; image[27354]=12; image[27355]=12; image[27356]=13; image[27357]=16; image[27358]=15; image[27359]=16; image[27360]=13; image[27361]=12; image[27362]=13; image[27363]=14; image[27364]=16; image[27365]=19; image[27366]=21; image[27367]=24; image[27368]=29; image[27369]=28; image[27370]=22; image[27371]=20; image[27372]=13; image[27373]=33; image[27374]=35; image[27375]=10; image[27376]=17; image[27377]=36; image[27378]=33; image[27379]=35; image[27380]=57; image[27381]=66; image[27382]=63; image[27383]=77; image[27384]=62; image[27385]=130; image[27386]=106; image[27387]=53; image[27388]=20; image[27389]=11; image[27390]=27; image[27391]=141; image[27392]=239; image[27393]=119; image[27394]=107; image[27395]=66; image[27396]=67; image[27397]=90; image[27398]=118; image[27399]=117; image[27400]=101; image[27401]=85; image[27402]=104; image[27403]=90; image[27404]=94; image[27405]=125; image[27406]=145; image[27407]=120; image[27408]=221; image[27409]=244; image[27410]=173; image[27411]=205; image[27412]=253; image[27413]=255; image[27414]=249; image[27415]=209; image[27416]=131; image[27417]=30; image[27418]=22; image[27419]=5; image[27420]=1; image[27421]=1; image[27422]=1; image[27423]=1; image[27424]=1; image[27425]=1; image[27426]=1; image[27427]=1; image[27428]=1; image[27429]=1; image[27430]=1; image[27431]=1; image[27432]=1; image[27433]=1; image[27434]=1; image[27435]=1; image[27436]=1; image[27437]=1; image[27438]=1; image[27439]=1; image[27440]=1; image[27441]=1; image[27442]=1; image[27443]=1; image[27444]=1; image[27445]=1; image[27446]=1; image[27447]=1; image[27448]=1; image[27449]=1; image[27450]=1; image[27451]=1; image[27452]=1; image[27453]=1; image[27454]=1; image[27455]=1; image[27456]=1; image[27457]=1; image[27458]=1; image[27459]=1; image[27460]=1; image[27461]=1; image[27462]=1; image[27463]=1; image[27464]=1; image[27465]=1; image[27466]=1; image[27467]=1; image[27468]=1; image[27469]=1; image[27470]=1; image[27471]=1; image[27472]=1; image[27473]=1; image[27474]=1; image[27475]=1; image[27476]=1; image[27477]=1; image[27478]=1; image[27479]=1; image[27480]=1; image[27481]=1; image[27482]=1; image[27483]=1; image[27484]=1; image[27485]=1; image[27486]=1; image[27487]=1; image[27488]=1; image[27489]=1; image[27490]=1; image[27491]=1; image[27492]=1; image[27493]=1; image[27494]=1; image[27495]=1; image[27496]=1; image[27497]=1; image[27498]=1; image[27499]=1; image[27500]=1; image[27501]=1; image[27502]=1; image[27503]=1; image[27504]=1; image[27505]=1; image[27506]=1; image[27507]=1; image[27508]=1; image[27509]=1; image[27510]=1; image[27511]=1; image[27512]=1; image[27513]=1; image[27514]=1; image[27515]=1; image[27516]=1; image[27517]=1; image[27518]=1; image[27519]=1; image[27520]=1; image[27521]=1; image[27522]=1; image[27523]=1; image[27524]=1; image[27525]=1; image[27526]=1; image[27527]=1; image[27528]=1; image[27529]=1; image[27530]=1; image[27531]=1; image[27532]=1; image[27533]=1; image[27534]=1; image[27535]=1; image[27536]=1; image[27537]=1; image[27538]=1; image[27539]=1; image[27540]=1; image[27541]=1; image[27542]=1; image[27543]=1; image[27544]=3; image[27545]=6; image[27546]=7; image[27547]=9; image[27548]=10; image[27549]=8; image[27550]=8; image[27551]=6; image[27552]=7; image[27553]=14; image[27554]=16; image[27555]=18; image[27556]=23; image[27557]=21; image[27558]=23; image[27559]=17; image[27560]=19; image[27561]=21; image[27562]=21; image[27563]=26; image[27564]=29; image[27565]=29; image[27566]=36; image[27567]=37; image[27568]=42; image[27569]=44; image[27570]=37; image[27571]=19; image[27572]=26; image[27573]=29; image[27574]=8; image[27575]=17; image[27576]=37; image[27577]=29; image[27578]=34; image[27579]=55; image[27580]=67; image[27581]=61; image[27582]=79; image[27583]=66; image[27584]=132; image[27585]=105; image[27586]=57; image[27587]=15; image[27588]=9; image[27589]=23; image[27590]=101; image[27591]=245; image[27592]=161; image[27593]=151; image[27594]=153; image[27595]=127; image[27596]=100; image[27597]=110; image[27598]=101; image[27599]=86; image[27600]=84; image[27601]=98; image[27602]=98; image[27603]=113; image[27604]=152; image[27605]=164; image[27606]=124; image[27607]=217; image[27608]=245; image[27609]=188; image[27610]=219; image[27611]=254; image[27612]=255; image[27613]=255; image[27614]=255; image[27615]=176; image[27616]=39; image[27617]=26; image[27618]=4; image[27619]=1; image[27620]=1; image[27621]=1; image[27622]=1; image[27623]=1; image[27624]=1; image[27625]=1; image[27626]=1; image[27627]=1; image[27628]=1; image[27629]=1; image[27630]=1; image[27631]=1; image[27632]=1; image[27633]=1; image[27634]=1; image[27635]=1; image[27636]=1; image[27637]=1; image[27638]=1; image[27639]=1; image[27640]=1; image[27641]=1; image[27642]=1; image[27643]=1; image[27644]=1; image[27645]=1; image[27646]=1; image[27647]=1; image[27648]=1; image[27649]=1; image[27650]=1; image[27651]=1; image[27652]=1; image[27653]=1; image[27654]=1; image[27655]=1; image[27656]=1; image[27657]=1; image[27658]=1; image[27659]=1; image[27660]=1; image[27661]=1; image[27662]=1; image[27663]=1; image[27664]=1; image[27665]=1; image[27666]=1; image[27667]=1; image[27668]=1; image[27669]=1; image[27670]=1; image[27671]=1; image[27672]=1; image[27673]=1; image[27674]=1; image[27675]=1; image[27676]=1; image[27677]=1; image[27678]=1; image[27679]=1; image[27680]=1; image[27681]=1; image[27682]=1; image[27683]=1; image[27684]=1; image[27685]=1; image[27686]=1; image[27687]=1; image[27688]=1; image[27689]=1; image[27690]=1; image[27691]=1; image[27692]=1; image[27693]=1; image[27694]=1; image[27695]=1; image[27696]=1; image[27697]=1; image[27698]=1; image[27699]=1; image[27700]=1; image[27701]=1; image[27702]=1; image[27703]=1; image[27704]=1; image[27705]=1; image[27706]=1; image[27707]=1; image[27708]=1; image[27709]=1; image[27710]=1; image[27711]=1; image[27712]=1; image[27713]=1; image[27714]=1; image[27715]=1; image[27716]=1; image[27717]=1; image[27718]=1; image[27719]=1; image[27720]=1; image[27721]=1; image[27722]=1; image[27723]=1; image[27724]=1; image[27725]=1; image[27726]=1; image[27727]=1; image[27728]=1; image[27729]=1; image[27730]=1; image[27731]=1; image[27732]=1; image[27733]=1; image[27734]=1; image[27735]=1; image[27736]=1; image[27737]=1; image[27738]=1; image[27739]=1; image[27740]=1; image[27741]=1; image[27742]=1; image[27743]=3; image[27744]=6; image[27745]=7; image[27746]=8; image[27747]=8; image[27748]=7; image[27749]=9; image[27750]=9; image[27751]=7; image[27752]=12; image[27753]=17; image[27754]=17; image[27755]=17; image[27756]=21; image[27757]=27; image[27758]=25; image[27759]=25; image[27760]=26; image[27761]=27; image[27762]=34; image[27763]=32; image[27764]=33; image[27765]=38; image[27766]=40; image[27767]=41; image[27768]=49; image[27769]=42; image[27770]=34; image[27771]=36; image[27772]=25; image[27773]=9; image[27774]=20; image[27775]=33; image[27776]=28; image[27777]=36; image[27778]=55; image[27779]=69; image[27780]=56; image[27781]=89; image[27782]=72; image[27783]=125; image[27784]=107; image[27785]=60; image[27786]=14; image[27787]=9; image[27788]=27; image[27789]=52; image[27790]=143; image[27791]=98; image[27792]=138; image[27793]=175; image[27794]=152; image[27795]=145; image[27796]=121; image[27797]=88; image[27798]=85; image[27799]=93; image[27800]=104; image[27801]=120; image[27802]=139; image[27803]=142; image[27804]=153; image[27805]=117; image[27806]=201; image[27807]=247; image[27808]=190; image[27809]=193; image[27810]=253; image[27811]=255; image[27812]=255; image[27813]=255; image[27814]=183; image[27815]=24; image[27816]=23; image[27817]=4; image[27818]=1; image[27819]=1; image[27820]=1; image[27821]=1; image[27822]=1; image[27823]=1; image[27824]=1; image[27825]=1; image[27826]=1; image[27827]=1; image[27828]=1; image[27829]=1; image[27830]=1; image[27831]=1; image[27832]=1; image[27833]=1; image[27834]=1; image[27835]=1; image[27836]=1; image[27837]=1; image[27838]=1; image[27839]=1; image[27840]=1; image[27841]=1; image[27842]=1; image[27843]=1; image[27844]=1; image[27845]=1; image[27846]=1; image[27847]=0; image[27848]=1; image[27849]=1; image[27850]=1; image[27851]=1; image[27852]=1; image[27853]=1; image[27854]=1; image[27855]=1; image[27856]=1; image[27857]=1; image[27858]=1; image[27859]=1; image[27860]=1; image[27861]=0; image[27862]=1; image[27863]=1; image[27864]=1; image[27865]=1; image[27866]=1; image[27867]=1; image[27868]=1; image[27869]=1; image[27870]=1; image[27871]=1; image[27872]=1; image[27873]=1; image[27874]=1; image[27875]=1; image[27876]=1; image[27877]=1; image[27878]=1; image[27879]=1; image[27880]=1; image[27881]=1; image[27882]=1; image[27883]=1; image[27884]=1; image[27885]=1; image[27886]=1; image[27887]=1; image[27888]=1; image[27889]=1; image[27890]=1; image[27891]=1; image[27892]=1; image[27893]=1; image[27894]=1; image[27895]=1; image[27896]=1; image[27897]=1; image[27898]=1; image[27899]=1; image[27900]=1; image[27901]=1; image[27902]=1; image[27903]=1; image[27904]=1; image[27905]=1; image[27906]=1; image[27907]=1; image[27908]=1; image[27909]=1; image[27910]=1; image[27911]=1; image[27912]=1; image[27913]=1; image[27914]=1; image[27915]=1; image[27916]=1; image[27917]=1; image[27918]=1; image[27919]=1; image[27920]=1; image[27921]=1; image[27922]=1; image[27923]=1; image[27924]=1; image[27925]=1; image[27926]=1; image[27927]=1; image[27928]=1; image[27929]=1; image[27930]=1; image[27931]=1; image[27932]=1; image[27933]=1; image[27934]=1; image[27935]=1; image[27936]=1; image[27937]=1; image[27938]=1; image[27939]=1; image[27940]=1; image[27941]=2; image[27942]=4; image[27943]=7; image[27944]=8; image[27945]=9; image[27946]=7; image[27947]=6; image[27948]=11; image[27949]=13; image[27950]=6; image[27951]=11; image[27952]=18; image[27953]=18; image[27954]=17; image[27955]=17; image[27956]=20; image[27957]=20; image[27958]=24; image[27959]=32; image[27960]=32; image[27961]=38; image[27962]=38; image[27963]=35; image[27964]=34; image[27965]=39; image[27966]=45; image[27967]=48; image[27968]=44; image[27969]=36; image[27970]=38; image[27971]=22; image[27972]=10; image[27973]=21; image[27974]=35; image[27975]=31; image[27976]=40; image[27977]=54; image[27978]=65; image[27979]=58; image[27980]=90; image[27981]=65; image[27982]=110; image[27983]=100; image[27984]=42; image[27985]=9; image[27986]=9; image[27987]=55; image[27988]=177; image[27989]=134; image[27990]=65; image[27991]=89; image[27992]=105; image[27993]=135; image[27994]=135; image[27995]=108; image[27996]=92; image[27997]=98; image[27998]=97; image[27999]=132; image[28000]=145; image[28001]=130; image[28002]=131; image[28003]=145; image[28004]=101; image[28005]=186; image[28006]=251; image[28007]=196; image[28008]=189; image[28009]=253; image[28010]=250; image[28011]=235; image[28012]=255; image[28013]=128; image[28014]=30; image[28015]=24; image[28016]=3; image[28017]=1; image[28018]=1; image[28019]=1; image[28020]=1; image[28021]=1; image[28022]=1; image[28023]=1; image[28024]=1; image[28025]=1; image[28026]=1; image[28027]=1; image[28028]=1; image[28029]=1; image[28030]=1; image[28031]=1; image[28032]=1; image[28033]=1; image[28034]=1; image[28035]=1; image[28036]=1; image[28037]=1; image[28038]=1; image[28039]=1; image[28040]=1; image[28041]=1; image[28042]=1; image[28043]=1; image[28044]=1; image[28045]=1; image[28046]=1; image[28047]=1; image[28048]=1; image[28049]=1; image[28050]=1; image[28051]=1; image[28052]=1; image[28053]=1; image[28054]=1; image[28055]=1; image[28056]=1; image[28057]=1; image[28058]=1; image[28059]=1; image[28060]=1; image[28061]=1; image[28062]=1; image[28063]=1; image[28064]=1; image[28065]=1; image[28066]=1; image[28067]=1; image[28068]=1; image[28069]=1; image[28070]=1; image[28071]=1; image[28072]=1; image[28073]=1; image[28074]=1; image[28075]=1; image[28076]=1; image[28077]=1; image[28078]=1; image[28079]=1; image[28080]=1; image[28081]=1; image[28082]=1; image[28083]=1; image[28084]=1; image[28085]=1; image[28086]=1; image[28087]=1; image[28088]=1; image[28089]=1; image[28090]=1; image[28091]=1; image[28092]=1; image[28093]=1; image[28094]=1; image[28095]=1; image[28096]=1; image[28097]=1; image[28098]=1; image[28099]=1; image[28100]=1; image[28101]=1; image[28102]=1; image[28103]=1; image[28104]=1; image[28105]=1; image[28106]=1; image[28107]=1; image[28108]=1; image[28109]=1; image[28110]=1; image[28111]=1; image[28112]=1; image[28113]=1; image[28114]=1; image[28115]=1; image[28116]=1; image[28117]=1; image[28118]=1; image[28119]=1; image[28120]=1; image[28121]=1; image[28122]=1; image[28123]=1; image[28124]=1; image[28125]=1; image[28126]=1; image[28127]=1; image[28128]=1; image[28129]=1; image[28130]=1; image[28131]=1; image[28132]=1; image[28133]=1; image[28134]=1; image[28135]=1; image[28136]=1; image[28137]=1; image[28138]=1; image[28139]=1; image[28140]=2; image[28141]=6; image[28142]=7; image[28143]=7; image[28144]=8; image[28145]=5; image[28146]=7; image[28147]=12; image[28148]=13; image[28149]=7; image[28150]=12; image[28151]=19; image[28152]=20; image[28153]=23; image[28154]=22; image[28155]=23; image[28156]=18; image[28157]=20; image[28158]=33; image[28159]=33; image[28160]=35; image[28161]=35; image[28162]=33; image[28163]=35; image[28164]=36; image[28165]=41; image[28166]=41; image[28167]=44; image[28168]=32; image[28169]=29; image[28170]=22; image[28171]=10; image[28172]=20; image[28173]=32; image[28174]=30; image[28175]=42; image[28176]=57; image[28177]=66; image[28178]=58; image[28179]=76; image[28180]=66; image[28181]=100; image[28182]=80; image[28183]=24; image[28184]=2; image[28185]=5; image[28186]=37; image[28187]=222; image[28188]=189; image[28189]=51; image[28190]=57; image[28191]=82; image[28192]=159; image[28193]=98; image[28194]=86; image[28195]=106; image[28196]=115; image[28197]=114; image[28198]=166; image[28199]=137; image[28200]=106; image[28201]=121; image[28202]=147; image[28203]=108; image[28204]=176; image[28205]=255; image[28206]=199; image[28207]=193; image[28208]=251; image[28209]=255; image[28210]=255; image[28211]=255; image[28212]=126; image[28213]=24; image[28214]=23; image[28215]=4; image[28216]=1; image[28217]=1; image[28218]=1; image[28219]=1; image[28220]=1; image[28221]=1; image[28222]=1; image[28223]=1; image[28224]=1; image[28225]=1; image[28226]=1; image[28227]=1; image[28228]=1; image[28229]=1; image[28230]=1; image[28231]=1; image[28232]=1; image[28233]=1; image[28234]=1; image[28235]=1; image[28236]=1; image[28237]=1; image[28238]=1; image[28239]=1; image[28240]=1; image[28241]=1; image[28242]=1; image[28243]=1; image[28244]=1; image[28245]=1; image[28246]=1; image[28247]=1; image[28248]=1; image[28249]=1; image[28250]=1; image[28251]=1; image[28252]=1; image[28253]=1; image[28254]=1; image[28255]=1; image[28256]=1; image[28257]=1; image[28258]=1; image[28259]=1; image[28260]=1; image[28261]=1; image[28262]=1; image[28263]=1; image[28264]=1; image[28265]=1; image[28266]=1; image[28267]=1; image[28268]=1; image[28269]=1; image[28270]=1; image[28271]=0; image[28272]=1; image[28273]=1; image[28274]=1; image[28275]=1; image[28276]=1; image[28277]=1; image[28278]=1; image[28279]=1; image[28280]=1; image[28281]=1; image[28282]=1; image[28283]=1; image[28284]=1; image[28285]=1; image[28286]=1; image[28287]=1; image[28288]=1; image[28289]=1; image[28290]=1; image[28291]=1; image[28292]=1; image[28293]=1; image[28294]=1; image[28295]=1; image[28296]=1; image[28297]=1; image[28298]=1; image[28299]=1; image[28300]=1; image[28301]=1; image[28302]=1; image[28303]=1; image[28304]=1; image[28305]=1; image[28306]=1; image[28307]=1; image[28308]=1; image[28309]=1; image[28310]=1; image[28311]=1; image[28312]=1; image[28313]=1; image[28314]=1; image[28315]=1; image[28316]=1; image[28317]=1; image[28318]=1; image[28319]=1; image[28320]=1; image[28321]=1; image[28322]=1; image[28323]=1; image[28324]=1; image[28325]=1; image[28326]=1; image[28327]=1; image[28328]=1; image[28329]=1; image[28330]=1; image[28331]=1; image[28332]=1; image[28333]=1; image[28334]=1; image[28335]=1; image[28336]=1; image[28337]=1; image[28338]=1; image[28339]=3; image[28340]=5; image[28341]=8; image[28342]=8; image[28343]=8; image[28344]=6; image[28345]=7; image[28346]=10; image[28347]=9; image[28348]=6; image[28349]=14; image[28350]=21; image[28351]=23; image[28352]=26; image[28353]=25; image[28354]=26; image[28355]=27; image[28356]=30; image[28357]=33; image[28358]=37; image[28359]=37; image[28360]=33; image[28361]=39; image[28362]=37; image[28363]=35; image[28364]=41; image[28365]=41; image[28366]=40; image[28367]=38; image[28368]=32; image[28369]=19; image[28370]=12; image[28371]=21; image[28372]=32; image[28373]=32; image[28374]=43; image[28375]=55; image[28376]=65; image[28377]=54; image[28378]=74; image[28379]=67; image[28380]=86; image[28381]=70; image[28382]=22; image[28383]=2; image[28384]=1; image[28385]=8; image[28386]=107; image[28387]=143; image[28388]=57; image[28389]=74; image[28390]=79; image[28391]=106; image[28392]=111; image[28393]=117; image[28394]=105; image[28395]=104; image[28396]=106; image[28397]=123; image[28398]=97; image[28399]=90; image[28400]=124; image[28401]=133; image[28402]=95; image[28403]=125; image[28404]=255; image[28405]=211; image[28406]=172; image[28407]=228; image[28408]=255; image[28409]=255; image[28410]=255; image[28411]=101; image[28412]=18; image[28413]=17; image[28414]=4; image[28415]=1; image[28416]=1; image[28417]=1; image[28418]=1; image[28419]=1; image[28420]=1; image[28421]=1; image[28422]=1; image[28423]=1; image[28424]=1; image[28425]=1; image[28426]=1; image[28427]=1; image[28428]=1; image[28429]=1; image[28430]=1; image[28431]=1; image[28432]=1; image[28433]=1; image[28434]=1; image[28435]=1; image[28436]=1; image[28437]=1; image[28438]=1; image[28439]=1; image[28440]=1; image[28441]=1; image[28442]=1; image[28443]=1; image[28444]=1; image[28445]=1; image[28446]=1; image[28447]=1; image[28448]=1; image[28449]=1; image[28450]=1; image[28451]=1; image[28452]=1; image[28453]=1; image[28454]=1; image[28455]=1; image[28456]=1; image[28457]=1; image[28458]=1; image[28459]=1; image[28460]=1; image[28461]=1; image[28462]=1; image[28463]=1; image[28464]=1; image[28465]=1; image[28466]=1; image[28467]=1; image[28468]=1; image[28469]=1; image[28470]=1; image[28471]=1; image[28472]=1; image[28473]=1; image[28474]=1; image[28475]=1; image[28476]=1; image[28477]=1; image[28478]=1; image[28479]=1; image[28480]=1; image[28481]=1; image[28482]=1; image[28483]=1; image[28484]=1; image[28485]=1; image[28486]=1; image[28487]=1; image[28488]=1; image[28489]=1; image[28490]=1; image[28491]=1; image[28492]=1; image[28493]=1; image[28494]=1; image[28495]=1; image[28496]=1; image[28497]=1; image[28498]=1; image[28499]=1; image[28500]=1; image[28501]=1; image[28502]=1; image[28503]=1; image[28504]=1; image[28505]=1; image[28506]=1; image[28507]=1; image[28508]=1; image[28509]=1; image[28510]=1; image[28511]=1; image[28512]=1; image[28513]=1; image[28514]=1; image[28515]=1; image[28516]=1; image[28517]=1; image[28518]=1; image[28519]=1; image[28520]=1; image[28521]=1; image[28522]=1; image[28523]=1; image[28524]=1; image[28525]=1; image[28526]=1; image[28527]=1; image[28528]=1; image[28529]=1; image[28530]=1; image[28531]=1; image[28532]=1; image[28533]=1; image[28534]=1; image[28535]=1; image[28536]=1; image[28537]=2; image[28538]=4; image[28539]=6; image[28540]=8; image[28541]=8; image[28542]=7; image[28543]=9; image[28544]=5; image[28545]=8; image[28546]=6; image[28547]=7; image[28548]=17; image[28549]=22; image[28550]=20; image[28551]=22; image[28552]=21; image[28553]=21; image[28554]=25; image[28555]=29; image[28556]=26; image[28557]=33; image[28558]=39; image[28559]=30; image[28560]=32; image[28561]=31; image[28562]=33; image[28563]=37; image[28564]=40; image[28565]=41; image[28566]=37; image[28567]=33; image[28568]=18; image[28569]=14; image[28570]=25; image[28571]=34; image[28572]=32; image[28573]=44; image[28574]=50; image[28575]=66; image[28576]=59; image[28577]=70; image[28578]=68; image[28579]=96; image[28580]=68; image[28581]=20; image[28582]=5; image[28583]=2; image[28584]=2; image[28585]=31; image[28586]=95; image[28587]=69; image[28588]=75; image[28589]=85; image[28590]=88; image[28591]=96; image[28592]=90; image[28593]=77; image[28594]=96; image[28595]=129; image[28596]=113; image[28597]=92; image[28598]=88; image[28599]=124; image[28600]=121; image[28601]=98; image[28602]=101; image[28603]=255; image[28604]=225; image[28605]=166; image[28606]=233; image[28607]=255; image[28608]=255; image[28609]=255; image[28610]=98; image[28611]=20; image[28612]=18; image[28613]=3; image[28614]=1; image[28615]=1; image[28616]=1; image[28617]=1; image[28618]=1; image[28619]=1; image[28620]=1; image[28621]=1; image[28622]=1; image[28623]=1; image[28624]=1; image[28625]=1; image[28626]=1; image[28627]=1; image[28628]=1; image[28629]=1; image[28630]=1; image[28631]=1; image[28632]=1; image[28633]=1; image[28634]=1; image[28635]=1; image[28636]=1; image[28637]=1; image[28638]=1; image[28639]=1; image[28640]=1; image[28641]=1; image[28642]=1; image[28643]=1; image[28644]=1; image[28645]=1; image[28646]=1; image[28647]=1; image[28648]=1; image[28649]=1; image[28650]=1; image[28651]=1; image[28652]=1; image[28653]=1; image[28654]=1; image[28655]=1; image[28656]=1; image[28657]=1; image[28658]=1; image[28659]=1; image[28660]=1; image[28661]=1; image[28662]=1; image[28663]=1; image[28664]=1; image[28665]=1; image[28666]=1; image[28667]=1; image[28668]=1; image[28669]=1; image[28670]=1; image[28671]=1; image[28672]=1; image[28673]=1; image[28674]=1; image[28675]=1; image[28676]=1; image[28677]=1; image[28678]=1; image[28679]=1; image[28680]=1; image[28681]=1; image[28682]=1; image[28683]=1; image[28684]=1; image[28685]=1; image[28686]=1; image[28687]=1; image[28688]=1; image[28689]=1; image[28690]=1; image[28691]=1; image[28692]=1; image[28693]=1; image[28694]=1; image[28695]=1; image[28696]=1; image[28697]=1; image[28698]=0; image[28699]=1; image[28700]=1; image[28701]=1; image[28702]=1; image[28703]=1; image[28704]=1; image[28705]=1; image[28706]=1; image[28707]=1; image[28708]=1; image[28709]=1; image[28710]=1; image[28711]=1; image[28712]=1; image[28713]=1; image[28714]=1; image[28715]=1; image[28716]=1; image[28717]=1; image[28718]=1; image[28719]=1; image[28720]=1; image[28721]=1; image[28722]=1; image[28723]=1; image[28724]=1; image[28725]=1; image[28726]=1; image[28727]=1; image[28728]=1; image[28729]=1; image[28730]=1; image[28731]=1; image[28732]=1; image[28733]=1; image[28734]=1; image[28735]=1; image[28736]=3; image[28737]=5; image[28738]=6; image[28739]=7; image[28740]=6; image[28741]=7; image[28742]=11; image[28743]=7; image[28744]=9; image[28745]=5; image[28746]=8; image[28747]=14; image[28748]=18; image[28749]=18; image[28750]=21; image[28751]=21; image[28752]=21; image[28753]=21; image[28754]=22; image[28755]=28; image[28756]=27; image[28757]=33; image[28758]=29; image[28759]=28; image[28760]=33; image[28761]=30; image[28762]=25; image[28763]=29; image[28764]=36; image[28765]=34; image[28766]=28; image[28767]=19; image[28768]=14; image[28769]=23; image[28770]=34; image[28771]=33; image[28772]=45; image[28773]=52; image[28774]=66; image[28775]=61; image[28776]=62; image[28777]=64; image[28778]=102; image[28779]=68; image[28780]=20; image[28781]=21; image[28782]=13; image[28783]=3; image[28784]=17; image[28785]=74; image[28786]=95; image[28787]=66; image[28788]=84; image[28789]=86; image[28790]=99; image[28791]=87; image[28792]=73; image[28793]=94; image[28794]=121; image[28795]=101; image[28796]=99; image[28797]=83; image[28798]=115; image[28799]=118; image[28800]=90; image[28801]=94; image[28802]=255; image[28803]=245; image[28804]=170; image[28805]=250; image[28806]=255; image[28807]=255; image[28808]=235; image[28809]=64; image[28810]=12; image[28811]=13; image[28812]=2; image[28813]=1; image[28814]=1; image[28815]=1; image[28816]=1; image[28817]=1; image[28818]=1; image[28819]=1; image[28820]=1; image[28821]=1; image[28822]=1; image[28823]=1; image[28824]=1; image[28825]=1; image[28826]=0; image[28827]=1; image[28828]=1; image[28829]=1; image[28830]=1; image[28831]=1; image[28832]=1; image[28833]=1; image[28834]=1; image[28835]=1; image[28836]=1; image[28837]=1; image[28838]=1; image[28839]=1; image[28840]=1; image[28841]=1; image[28842]=1; image[28843]=1; image[28844]=1; image[28845]=1; image[28846]=1; image[28847]=1; image[28848]=1; image[28849]=1; image[28850]=1; image[28851]=1; image[28852]=1; image[28853]=1; image[28854]=1; image[28855]=1; image[28856]=1; image[28857]=1; image[28858]=1; image[28859]=1; image[28860]=1; image[28861]=1; image[28862]=1; image[28863]=1; image[28864]=1; image[28865]=1; image[28866]=1; image[28867]=1; image[28868]=1; image[28869]=1; image[28870]=1; image[28871]=1; image[28872]=1; image[28873]=1; image[28874]=1; image[28875]=1; image[28876]=1; image[28877]=1; image[28878]=1; image[28879]=1; image[28880]=1; image[28881]=1; image[28882]=1; image[28883]=1; image[28884]=1; image[28885]=1; image[28886]=1; image[28887]=1; image[28888]=1; image[28889]=1; image[28890]=1; image[28891]=1; image[28892]=1; image[28893]=1; image[28894]=1; image[28895]=1; image[28896]=1; image[28897]=1; image[28898]=1; image[28899]=1; image[28900]=1; image[28901]=1; image[28902]=1; image[28903]=1; image[28904]=1; image[28905]=1; image[28906]=1; image[28907]=1; image[28908]=1; image[28909]=1; image[28910]=1; image[28911]=1; image[28912]=1; image[28913]=1; image[28914]=1; image[28915]=1; image[28916]=1; image[28917]=1; image[28918]=1; image[28919]=1; image[28920]=1; image[28921]=1; image[28922]=1; image[28923]=1; image[28924]=1; image[28925]=1; image[28926]=1; image[28927]=1; image[28928]=1; image[28929]=1; image[28930]=1; image[28931]=1; image[28932]=1; image[28933]=1; image[28934]=2; image[28935]=4; image[28936]=6; image[28937]=7; image[28938]=7; image[28939]=7; image[28940]=9; image[28941]=14; image[28942]=7; image[28943]=6; image[28944]=6; image[28945]=10; image[28946]=17; image[28947]=15; image[28948]=15; image[28949]=20; image[28950]=21; image[28951]=24; image[28952]=25; image[28953]=24; image[28954]=25; image[28955]=25; image[28956]=30; image[28957]=30; image[28958]=28; image[28959]=36; image[28960]=34; image[28961]=31; image[28962]=31; image[28963]=30; image[28964]=28; image[28965]=17; image[28966]=15; image[28967]=15; image[28968]=23; image[28969]=32; image[28970]=33; image[28971]=47; image[28972]=54; image[28973]=64; image[28974]=59; image[28975]=60; image[28976]=65; image[28977]=106; image[28978]=70; image[28979]=14; image[28980]=32; image[28981]=48; image[28982]=18; image[28983]=14; image[28984]=52; image[28985]=116; image[28986]=74; image[28987]=84; image[28988]=97; image[28989]=93; image[28990]=92; image[28991]=84; image[28992]=78; image[28993]=81; image[28994]=82; image[28995]=108; image[28996]=86; image[28997]=110; image[28998]=134; image[28999]=85; image[29000]=93; image[29001]=240; image[29002]=255; image[29003]=222; image[29004]=253; image[29005]=255; image[29006]=255; image[29007]=255; image[29008]=98; image[29009]=14; image[29010]=13; image[29011]=2; image[29012]=1; image[29013]=1; image[29014]=1; image[29015]=1; image[29016]=1; image[29017]=1; image[29018]=1; image[29019]=1; image[29020]=1; image[29021]=1; image[29022]=1; image[29023]=1; image[29024]=1; image[29025]=1; image[29026]=1; image[29027]=1; image[29028]=1; image[29029]=1; image[29030]=1; image[29031]=1; image[29032]=1; image[29033]=1; image[29034]=1; image[29035]=1; image[29036]=1; image[29037]=1; image[29038]=1; image[29039]=1; image[29040]=1; image[29041]=1; image[29042]=1; image[29043]=1; image[29044]=1; image[29045]=1; image[29046]=1; image[29047]=1; image[29048]=1; image[29049]=1; image[29050]=1; image[29051]=1; image[29052]=1; image[29053]=1; image[29054]=1; image[29055]=1; image[29056]=1; image[29057]=1; image[29058]=1; image[29059]=1; image[29060]=1; image[29061]=1; image[29062]=1; image[29063]=1; image[29064]=1; image[29065]=1; image[29066]=1; image[29067]=1; image[29068]=1; image[29069]=1; image[29070]=1; image[29071]=1; image[29072]=1; image[29073]=1; image[29074]=1; image[29075]=1; image[29076]=1; image[29077]=1; image[29078]=1; image[29079]=1; image[29080]=1; image[29081]=1; image[29082]=1; image[29083]=1; image[29084]=1; image[29085]=1; image[29086]=1; image[29087]=1; image[29088]=1; image[29089]=1; image[29090]=1; image[29091]=1; image[29092]=1; image[29093]=1; image[29094]=1; image[29095]=1; image[29096]=1; image[29097]=1; image[29098]=1; image[29099]=1; image[29100]=1; image[29101]=1; image[29102]=1; image[29103]=1; image[29104]=1; image[29105]=1; image[29106]=1; image[29107]=1; image[29108]=1; image[29109]=1; image[29110]=1; image[29111]=1; image[29112]=1; image[29113]=1; image[29114]=1; image[29115]=1; image[29116]=1; image[29117]=1; image[29118]=1; image[29119]=1; image[29120]=1; image[29121]=1; image[29122]=1; image[29123]=1; image[29124]=1; image[29125]=1; image[29126]=1; image[29127]=1; image[29128]=1; image[29129]=1; image[29130]=1; image[29131]=1; image[29132]=2; image[29133]=3; image[29134]=4; image[29135]=6; image[29136]=8; image[29137]=8; image[29138]=7; image[29139]=9; image[29140]=12; image[29141]=5; image[29142]=3; image[29143]=7; image[29144]=10; image[29145]=14; image[29146]=16; image[29147]=19; image[29148]=23; image[29149]=24; image[29150]=21; image[29151]=21; image[29152]=25; image[29153]=27; image[29154]=27; image[29155]=28; image[29156]=30; image[29157]=28; image[29158]=33; image[29159]=34; image[29160]=33; image[29161]=40; image[29162]=42; image[29163]=39; image[29164]=29; image[29165]=17; image[29166]=18; image[29167]=24; image[29168]=30; image[29169]=33; image[29170]=46; image[29171]=48; image[29172]=55; image[29173]=55; image[29174]=56; image[29175]=69; image[29176]=113; image[29177]=60; image[29178]=5; image[29179]=23; image[29180]=59; image[29181]=38; image[29182]=16; image[29183]=44; image[29184]=101; image[29185]=85; image[29186]=79; image[29187]=109; image[29188]=76; image[29189]=87; image[29190]=96; image[29191]=79; image[29192]=66; image[29193]=73; image[29194]=93; image[29195]=96; image[29196]=100; image[29197]=120; image[29198]=80; image[29199]=82; image[29200]=167; image[29201]=255; image[29202]=252; image[29203]=255; image[29204]=255; image[29205]=255; image[29206]=255; image[29207]=93; image[29208]=14; image[29209]=15; image[29210]=2; image[29211]=1; image[29212]=1; image[29213]=1; image[29214]=1; image[29215]=1; image[29216]=1; image[29217]=1; image[29218]=1; image[29219]=1; image[29220]=1; image[29221]=1; image[29222]=1; image[29223]=1; image[29224]=1; image[29225]=1; image[29226]=1; image[29227]=1; image[29228]=1; image[29229]=1; image[29230]=1; image[29231]=1; image[29232]=1; image[29233]=1; image[29234]=1; image[29235]=1; image[29236]=1; image[29237]=1; image[29238]=1; image[29239]=1; image[29240]=1; image[29241]=1; image[29242]=1; image[29243]=1; image[29244]=1; image[29245]=1; image[29246]=1; image[29247]=1; image[29248]=1; image[29249]=1; image[29250]=1; image[29251]=1; image[29252]=1; image[29253]=1; image[29254]=1; image[29255]=1; image[29256]=1; image[29257]=1; image[29258]=1; image[29259]=1; image[29260]=1; image[29261]=1; image[29262]=1; image[29263]=1; image[29264]=1; image[29265]=1; image[29266]=1; image[29267]=1; image[29268]=1; image[29269]=1; image[29270]=1; image[29271]=1; image[29272]=1; image[29273]=1; image[29274]=1; image[29275]=1; image[29276]=1; image[29277]=1; image[29278]=1; image[29279]=1; image[29280]=1; image[29281]=1; image[29282]=1; image[29283]=1; image[29284]=1; image[29285]=1; image[29286]=1; image[29287]=1; image[29288]=1; image[29289]=1; image[29290]=1; image[29291]=1; image[29292]=1; image[29293]=1; image[29294]=1; image[29295]=1; image[29296]=1; image[29297]=1; image[29298]=1; image[29299]=1; image[29300]=1; image[29301]=1; image[29302]=1; image[29303]=1; image[29304]=1; image[29305]=1; image[29306]=1; image[29307]=1; image[29308]=1; image[29309]=1; image[29310]=1; image[29311]=1; image[29312]=1; image[29313]=1; image[29314]=1; image[29315]=1; image[29316]=1; image[29317]=1; image[29318]=1; image[29319]=1; image[29320]=1; image[29321]=1; image[29322]=1; image[29323]=1; image[29324]=1; image[29325]=2; image[29326]=1; image[29327]=1; image[29328]=1; image[29329]=1; image[29330]=1; image[29331]=3; image[29332]=5; image[29333]=5; image[29334]=6; image[29335]=7; image[29336]=8; image[29337]=8; image[29338]=10; image[29339]=8; image[29340]=4; image[29341]=4; image[29342]=9; image[29343]=10; image[29344]=12; image[29345]=16; image[29346]=16; image[29347]=18; image[29348]=20; image[29349]=20; image[29350]=20; image[29351]=22; image[29352]=24; image[29353]=27; image[29354]=26; image[29355]=26; image[29356]=24; image[29357]=30; image[29358]=37; image[29359]=35; image[29360]=44; image[29361]=47; image[29362]=33; image[29363]=27; image[29364]=14; image[29365]=21; image[29366]=25; image[29367]=28; image[29368]=34; image[29369]=45; image[29370]=44; image[29371]=54; image[29372]=50; image[29373]=56; image[29374]=64; image[29375]=108; image[29376]=73; image[29377]=12; image[29378]=20; image[29379]=62; image[29380]=48; image[29381]=20; image[29382]=38; image[29383]=70; image[29384]=83; image[29385]=72; image[29386]=93; image[29387]=75; image[29388]=96; image[29389]=110; image[29390]=88; image[29391]=64; image[29392]=81; image[29393]=71; image[29394]=82; image[29395]=101; image[29396]=94; image[29397]=71; image[29398]=79; image[29399]=137; image[29400]=250; image[29401]=255; image[29402]=255; image[29403]=255; image[29404]=255; image[29405]=230; image[29406]=64; image[29407]=13; image[29408]=14; image[29409]=2; image[29410]=1; image[29411]=1; image[29412]=1; image[29413]=1; image[29414]=1; image[29415]=1; image[29416]=1; image[29417]=1; image[29418]=1; image[29419]=1; image[29420]=1; image[29421]=1; image[29422]=1; image[29423]=1; image[29424]=1; image[29425]=1; image[29426]=1; image[29427]=1; image[29428]=1; image[29429]=1; image[29430]=1; image[29431]=1; image[29432]=1; image[29433]=1; image[29434]=1; image[29435]=1; image[29436]=1; image[29437]=1; image[29438]=1; image[29439]=1; image[29440]=1; image[29441]=1; image[29442]=1; image[29443]=1; image[29444]=1; image[29445]=1; image[29446]=1; image[29447]=1; image[29448]=1; image[29449]=1; image[29450]=1; image[29451]=1; image[29452]=1; image[29453]=1; image[29454]=1; image[29455]=1; image[29456]=1; image[29457]=1; image[29458]=1; image[29459]=1; image[29460]=1; image[29461]=1; image[29462]=1; image[29463]=1; image[29464]=1; image[29465]=1; image[29466]=1; image[29467]=1; image[29468]=1; image[29469]=1; image[29470]=1; image[29471]=1; image[29472]=1; image[29473]=1; image[29474]=1; image[29475]=0; image[29476]=1; image[29477]=1; image[29478]=1; image[29479]=1; image[29480]=1; image[29481]=1; image[29482]=1; image[29483]=1; image[29484]=1; image[29485]=1; image[29486]=1; image[29487]=1; image[29488]=1; image[29489]=1; image[29490]=1; image[29491]=1; image[29492]=1; image[29493]=1; image[29494]=1; image[29495]=1; image[29496]=1; image[29497]=1; image[29498]=1; image[29499]=1; image[29500]=1; image[29501]=1; image[29502]=1; image[29503]=1; image[29504]=1; image[29505]=1; image[29506]=1; image[29507]=1; image[29508]=1; image[29509]=1; image[29510]=1; image[29511]=1; image[29512]=1; image[29513]=1; image[29514]=1; image[29515]=1; image[29516]=1; image[29517]=1; image[29518]=1; image[29519]=1; image[29520]=1; image[29521]=1; image[29522]=1; image[29523]=1; image[29524]=1; image[29525]=1; image[29526]=1; image[29527]=1; image[29528]=2; image[29529]=2; image[29530]=3; image[29531]=5; image[29532]=5; image[29533]=9; image[29534]=9; image[29535]=8; image[29536]=8; image[29537]=8; image[29538]=5; image[29539]=4; image[29540]=6; image[29541]=9; image[29542]=10; image[29543]=12; image[29544]=14; image[29545]=14; image[29546]=15; image[29547]=15; image[29548]=14; image[29549]=18; image[29550]=19; image[29551]=21; image[29552]=21; image[29553]=22; image[29554]=23; image[29555]=25; image[29556]=25; image[29557]=28; image[29558]=32; image[29559]=35; image[29560]=39; image[29561]=32; image[29562]=23; image[29563]=14; image[29564]=21; image[29565]=24; image[29566]=26; image[29567]=33; image[29568]=47; image[29569]=43; image[29570]=53; image[29571]=49; image[29572]=58; image[29573]=58; image[29574]=99; image[29575]=80; image[29576]=18; image[29577]=12; image[29578]=54; image[29579]=54; image[29580]=37; image[29581]=41; image[29582]=54; image[29583]=89; image[29584]=81; image[29585]=77; image[29586]=78; image[29587]=89; image[29588]=102; image[29589]=88; image[29590]=70; image[29591]=76; image[29592]=66; image[29593]=69; image[29594]=81; image[29595]=82; image[29596]=62; image[29597]=71; image[29598]=126; image[29599]=225; image[29600]=255; image[29601]=255; image[29602]=255; image[29603]=255; image[29604]=241; image[29605]=70; image[29606]=16; image[29607]=14; image[29608]=2; image[29609]=1; image[29610]=1; image[29611]=1; image[29612]=1; image[29613]=1; image[29614]=1; image[29615]=1; image[29616]=1; image[29617]=1; image[29618]=1; image[29619]=1; image[29620]=1; image[29621]=1; image[29622]=1; image[29623]=1; image[29624]=1; image[29625]=1; image[29626]=1; image[29627]=1; image[29628]=1; image[29629]=1; image[29630]=1; image[29631]=1; image[29632]=1; image[29633]=1; image[29634]=1; image[29635]=1; image[29636]=1; image[29637]=1; image[29638]=1; image[29639]=1; image[29640]=1; image[29641]=1; image[29642]=1; image[29643]=1; image[29644]=1; image[29645]=1; image[29646]=1; image[29647]=1; image[29648]=1; image[29649]=1; image[29650]=1; image[29651]=1; image[29652]=1; image[29653]=1; image[29654]=1; image[29655]=1; image[29656]=1; image[29657]=1; image[29658]=1; image[29659]=1; image[29660]=1; image[29661]=1; image[29662]=1; image[29663]=1; image[29664]=1; image[29665]=1; image[29666]=1; image[29667]=1; image[29668]=1; image[29669]=1; image[29670]=1; image[29671]=1; image[29672]=1; image[29673]=1; image[29674]=1; image[29675]=1; image[29676]=1; image[29677]=1; image[29678]=1; image[29679]=1; image[29680]=1; image[29681]=1; image[29682]=1; image[29683]=1; image[29684]=1; image[29685]=1; image[29686]=1; image[29687]=1; image[29688]=1; image[29689]=1; image[29690]=1; image[29691]=1; image[29692]=1; image[29693]=1; image[29694]=1; image[29695]=1; image[29696]=1; image[29697]=1; image[29698]=1; image[29699]=1; image[29700]=1; image[29701]=1; image[29702]=1; image[29703]=1; image[29704]=1; image[29705]=1; image[29706]=1; image[29707]=1; image[29708]=1; image[29709]=1; image[29710]=1; image[29711]=1; image[29712]=1; image[29713]=1; image[29714]=1; image[29715]=1; image[29716]=1; image[29717]=1; image[29718]=1; image[29719]=1; image[29720]=1; image[29721]=1; image[29722]=1; image[29723]=1; image[29724]=1; image[29725]=1; image[29726]=2; image[29727]=2; image[29728]=3; image[29729]=5; image[29730]=5; image[29731]=6; image[29732]=9; image[29733]=9; image[29734]=8; image[29735]=6; image[29736]=7; image[29737]=5; image[29738]=3; image[29739]=5; image[29740]=6; image[29741]=8; image[29742]=9; image[29743]=12; image[29744]=12; image[29745]=11; image[29746]=13; image[29747]=12; image[29748]=14; image[29749]=14; image[29750]=15; image[29751]=15; image[29752]=15; image[29753]=17; image[29754]=20; image[29755]=22; image[29756]=23; image[29757]=26; image[29758]=30; image[29759]=27; image[29760]=25; image[29761]=21; image[29762]=12; image[29763]=23; image[29764]=27; image[29765]=28; image[29766]=29; image[29767]=43; image[29768]=44; image[29769]=52; image[29770]=51; image[29771]=51; image[29772]=56; image[29773]=88; image[29774]=56; image[29775]=12; image[29776]=8; image[29777]=50; image[29778]=65; image[29779]=58; image[29780]=55; image[29781]=57; image[29782]=85; image[29783]=76; image[29784]=68; image[29785]=83; image[29786]=85; image[29787]=83; image[29788]=77; image[29789]=74; image[29790]=62; image[29791]=55; image[29792]=68; image[29793]=67; image[29794]=88; image[29795]=67; image[29796]=60; image[29797]=112; image[29798]=147; image[29799]=202; image[29800]=254; image[29801]=255; image[29802]=239; image[29803]=167; image[29804]=46; image[29805]=16; image[29806]=14; image[29807]=2; image[29808]=1; image[29809]=1; image[29810]=1; image[29811]=1; image[29812]=1; image[29813]=1; image[29814]=1; image[29815]=1; image[29816]=1; image[29817]=1; image[29818]=1; image[29819]=1; image[29820]=1; image[29821]=1; image[29822]=1; image[29823]=1; image[29824]=1; image[29825]=1; image[29826]=1; image[29827]=1; image[29828]=1; image[29829]=1; image[29830]=1; image[29831]=1; image[29832]=1; image[29833]=1; image[29834]=1; image[29835]=1; image[29836]=1; image[29837]=1; image[29838]=1; image[29839]=1; image[29840]=1; image[29841]=1; image[29842]=1; image[29843]=1; image[29844]=1; image[29845]=1; image[29846]=1; image[29847]=1; image[29848]=1; image[29849]=1; image[29850]=1; image[29851]=1; image[29852]=1; image[29853]=1; image[29854]=1; image[29855]=1; image[29856]=1; image[29857]=1; image[29858]=1; image[29859]=1; image[29860]=1; image[29861]=1; image[29862]=1; image[29863]=1; image[29864]=1; image[29865]=1; image[29866]=1; image[29867]=1; image[29868]=1; image[29869]=1; image[29870]=1; image[29871]=1; image[29872]=1; image[29873]=1; image[29874]=1; image[29875]=1; image[29876]=1; image[29877]=1; image[29878]=1; image[29879]=1; image[29880]=1; image[29881]=1; image[29882]=1; image[29883]=1; image[29884]=1; image[29885]=1; image[29886]=1; image[29887]=1; image[29888]=1; image[29889]=1; image[29890]=1; image[29891]=1; image[29892]=1; image[29893]=1; image[29894]=1; image[29895]=1; image[29896]=1; image[29897]=1; image[29898]=1; image[29899]=1; image[29900]=1; image[29901]=1; image[29902]=1; image[29903]=1; image[29904]=1; image[29905]=1; image[29906]=1; image[29907]=1; image[29908]=1; image[29909]=1; image[29910]=1; image[29911]=1; image[29912]=1; image[29913]=1; image[29914]=1; image[29915]=1; image[29916]=1; image[29917]=1; image[29918]=1; image[29919]=1; image[29920]=1; image[29921]=1; image[29922]=1; image[29923]=2; image[29924]=2; image[29925]=2; image[29926]=3; image[29927]=4; image[29928]=6; image[29929]=6; image[29930]=6; image[29931]=8; image[29932]=9; image[29933]=8; image[29934]=7; image[29935]=8; image[29936]=4; image[29937]=2; image[29938]=2; image[29939]=3; image[29940]=3; image[29941]=4; image[29942]=9; image[29943]=9; image[29944]=10; image[29945]=9; image[29946]=8; image[29947]=9; image[29948]=10; image[29949]=13; image[29950]=13; image[29951]=13; image[29952]=13; image[29953]=12; image[29954]=15; image[29955]=17; image[29956]=20; image[29957]=27; image[29958]=24; image[29959]=20; image[29960]=19; image[29961]=11; image[29962]=24; image[29963]=23; image[29964]=27; image[29965]=32; image[29966]=39; image[29967]=39; image[29968]=48; image[29969]=53; image[29970]=49; image[29971]=58; image[29972]=84; image[29973]=41; image[29974]=8; image[29975]=5; image[29976]=42; image[29977]=67; image[29978]=67; image[29979]=85; image[29980]=78; image[29981]=43; image[29982]=52; image[29983]=74; image[29984]=73; image[29985]=77; image[29986]=79; image[29987]=76; image[29988]=68; image[29989]=56; image[29990]=52; image[29991]=55; image[29992]=52; image[29993]=73; image[29994]=69; image[29995]=62; image[29996]=117; image[29997]=126; image[29998]=164; image[29999]=254; image[30000]=255; image[30001]=214; image[30002]=210; image[30003]=78; image[30004]=20; image[30005]=16; image[30006]=1; image[30007]=1; image[30008]=1; image[30009]=1; image[30010]=1; image[30011]=1; image[30012]=1; image[30013]=1; image[30014]=1; image[30015]=1; image[30016]=1; image[30017]=1; image[30018]=1; image[30019]=1; image[30020]=1; image[30021]=1; image[30022]=1; image[30023]=1; image[30024]=1; image[30025]=1; image[30026]=1; image[30027]=1; image[30028]=1; image[30029]=1; image[30030]=1; image[30031]=1; image[30032]=1; image[30033]=1; image[30034]=1; image[30035]=1; image[30036]=1; image[30037]=1; image[30038]=1; image[30039]=1; image[30040]=1; image[30041]=1; image[30042]=1; image[30043]=1; image[30044]=1; image[30045]=1; image[30046]=1; image[30047]=1; image[30048]=1; image[30049]=1; image[30050]=1; image[30051]=1; image[30052]=1; image[30053]=1; image[30054]=1; image[30055]=1; image[30056]=1; image[30057]=1; image[30058]=1; image[30059]=1; image[30060]=1; image[30061]=1; image[30062]=1; image[30063]=1; image[30064]=1; image[30065]=1; image[30066]=1; image[30067]=1; image[30068]=1; image[30069]=1; image[30070]=1; image[30071]=1; image[30072]=1; image[30073]=1; image[30074]=1; image[30075]=1; image[30076]=1; image[30077]=1; image[30078]=1; image[30079]=1; image[30080]=1; image[30081]=1; image[30082]=1; image[30083]=1; image[30084]=1; image[30085]=1; image[30086]=1; image[30087]=1; image[30088]=1; image[30089]=1; image[30090]=1; image[30091]=1; image[30092]=1; image[30093]=1; image[30094]=1; image[30095]=1; image[30096]=1; image[30097]=1; image[30098]=1; image[30099]=1; image[30100]=1; image[30101]=1; image[30102]=1; image[30103]=1; image[30104]=1; image[30105]=1; image[30106]=1; image[30107]=1; image[30108]=1; image[30109]=1; image[30110]=1; image[30111]=1; image[30112]=1; image[30113]=1; image[30114]=1; image[30115]=1; image[30116]=1; image[30117]=1; image[30118]=1; image[30119]=1; image[30120]=1; image[30121]=2; image[30122]=2; image[30123]=2; image[30124]=2; image[30125]=3; image[30126]=4; image[30127]=6; image[30128]=5; image[30129]=6; image[30130]=8; image[30131]=8; image[30132]=8; image[30133]=8; image[30134]=10; image[30135]=4; image[30136]=3; image[30137]=4; image[30138]=3; image[30139]=2; image[30140]=2; image[30141]=4; image[30142]=5; image[30143]=5; image[30144]=5; image[30145]=5; image[30146]=6; image[30147]=7; image[30148]=9; image[30149]=8; image[30150]=11; image[30151]=13; image[30152]=11; image[30153]=12; image[30154]=9; image[30155]=10; image[30156]=13; image[30157]=15; image[30158]=17; image[30159]=15; image[30160]=10; image[30161]=24; image[30162]=21; image[30163]=23; image[30164]=32; image[30165]=39; image[30166]=41; image[30167]=53; image[30168]=54; image[30169]=48; image[30170]=59; image[30171]=93; image[30172]=39; image[30173]=4; image[30174]=3; image[30175]=34; image[30176]=64; image[30177]=49; image[30178]=44; image[30179]=35; image[30180]=75; image[30181]=118; image[30182]=114; image[30183]=78; image[30184]=69; image[30185]=74; image[30186]=68; image[30187]=68; image[30188]=56; image[30189]=49; image[30190]=42; image[30191]=39; image[30192]=73; image[30193]=82; image[30194]=69; image[30195]=127; image[30196]=120; image[30197]=152; image[30198]=224; image[30199]=255; image[30200]=207; image[30201]=177; image[30202]=64; image[30203]=20; image[30204]=15; image[30205]=1; image[30206]=1; image[30207]=1; image[30208]=1; image[30209]=1; image[30210]=1; image[30211]=1; image[30212]=1; image[30213]=1; image[30214]=1; image[30215]=1; image[30216]=1; image[30217]=1; image[30218]=1; image[30219]=1; image[30220]=1; image[30221]=1; image[30222]=1; image[30223]=1; image[30224]=1; image[30225]=1; image[30226]=1; image[30227]=1; image[30228]=1; image[30229]=1; image[30230]=1; image[30231]=1; image[30232]=1; image[30233]=1; image[30234]=1; image[30235]=1; image[30236]=1; image[30237]=1; image[30238]=0; image[30239]=1; image[30240]=1; image[30241]=1; image[30242]=1; image[30243]=1; image[30244]=1; image[30245]=1; image[30246]=1; image[30247]=1; image[30248]=1; image[30249]=1; image[30250]=1; image[30251]=1; image[30252]=1; image[30253]=1; image[30254]=1; image[30255]=1; image[30256]=1; image[30257]=1; image[30258]=1; image[30259]=1; image[30260]=1; image[30261]=1; image[30262]=1; image[30263]=1; image[30264]=1; image[30265]=1; image[30266]=1; image[30267]=1; image[30268]=1; image[30269]=1; image[30270]=1; image[30271]=1; image[30272]=1; image[30273]=1; image[30274]=1; image[30275]=1; image[30276]=1; image[30277]=1; image[30278]=1; image[30279]=1; image[30280]=1; image[30281]=1; image[30282]=1; image[30283]=1; image[30284]=1; image[30285]=1; image[30286]=1; image[30287]=1; image[30288]=1; image[30289]=1; image[30290]=1; image[30291]=1; image[30292]=1; image[30293]=1; image[30294]=1; image[30295]=1; image[30296]=1; image[30297]=1; image[30298]=1; image[30299]=1; image[30300]=1; image[30301]=1; image[30302]=1; image[30303]=1; image[30304]=1; image[30305]=1; image[30306]=1; image[30307]=1; image[30308]=1; image[30309]=1; image[30310]=1; image[30311]=1; image[30312]=1; image[30313]=1; image[30314]=1; image[30315]=1; image[30316]=1; image[30317]=1; image[30318]=1; image[30319]=1; image[30320]=1; image[30321]=1; image[30322]=1; image[30323]=2; image[30324]=3; image[30325]=4; image[30326]=6; image[30327]=5; image[30328]=6; image[30329]=8; image[30330]=7; image[30331]=9; image[30332]=11; image[30333]=12; image[30334]=3; image[30335]=5; image[30336]=8; image[30337]=9; image[30338]=9; image[30339]=9; image[30340]=12; image[30341]=15; image[30342]=12; image[30343]=12; image[30344]=12; image[30345]=10; image[30346]=11; image[30347]=12; image[30348]=11; image[30349]=11; image[30350]=8; image[30351]=7; image[30352]=8; image[30353]=7; image[30354]=8; image[30355]=11; image[30356]=13; image[30357]=16; image[30358]=11; image[30359]=9; image[30360]=21; image[30361]=22; image[30362]=24; image[30363]=33; image[30364]=43; image[30365]=42; image[30366]=55; image[30367]=51; image[30368]=49; image[30369]=62; image[30370]=110; image[30371]=43; image[30372]=1; image[30373]=2; image[30374]=20; image[30375]=54; image[30376]=55; image[30377]=66; image[30378]=144; image[30379]=244; image[30380]=175; image[30381]=83; image[30382]=70; image[30383]=72; image[30384]=78; image[30385]=72; image[30386]=80; image[30387]=69; image[30388]=64; image[30389]=44; image[30390]=35; image[30391]=87; image[30392]=107; image[30393]=55; image[30394]=91; image[30395]=116; image[30396]=133; image[30397]=183; image[30398]=217; image[30399]=170; image[30400]=146; image[30401]=53; image[30402]=17; image[30403]=12; image[30404]=2; image[30405]=1; image[30406]=1; image[30407]=1; image[30408]=1; image[30409]=1; image[30410]=1; image[30411]=1; image[30412]=1; image[30413]=1; image[30414]=1; image[30415]=1; image[30416]=1; image[30417]=1; image[30418]=1; image[30419]=1; image[30420]=1; image[30421]=1; image[30422]=1; image[30423]=1; image[30424]=1; image[30425]=1; image[30426]=1; image[30427]=1; image[30428]=1; image[30429]=1; image[30430]=1; image[30431]=1; image[30432]=1; image[30433]=1; image[30434]=1; image[30435]=1; image[30436]=1; image[30437]=1; image[30438]=1; image[30439]=1; image[30440]=1; image[30441]=1; image[30442]=1; image[30443]=1; image[30444]=1; image[30445]=1; image[30446]=1; image[30447]=1; image[30448]=1; image[30449]=1; image[30450]=1; image[30451]=1; image[30452]=1; image[30453]=1; image[30454]=1; image[30455]=1; image[30456]=1; image[30457]=1; image[30458]=1; image[30459]=1; image[30460]=1; image[30461]=1; image[30462]=1; image[30463]=1; image[30464]=1; image[30465]=1; image[30466]=1; image[30467]=1; image[30468]=1; image[30469]=1; image[30470]=1; image[30471]=1; image[30472]=1; image[30473]=1; image[30474]=1; image[30475]=1; image[30476]=1; image[30477]=1; image[30478]=1; image[30479]=1; image[30480]=1; image[30481]=1; image[30482]=1; image[30483]=1; image[30484]=1; image[30485]=1; image[30486]=1; image[30487]=1; image[30488]=1; image[30489]=1; image[30490]=1; image[30491]=1; image[30492]=1; image[30493]=1; image[30494]=1; image[30495]=1; image[30496]=1; image[30497]=1; image[30498]=1; image[30499]=1; image[30500]=1; image[30501]=1; image[30502]=1; image[30503]=1; image[30504]=1; image[30505]=1; image[30506]=1; image[30507]=1; image[30508]=1; image[30509]=1; image[30510]=1; image[30511]=1; image[30512]=1; image[30513]=1; image[30514]=1; image[30515]=1; image[30516]=1; image[30517]=1; image[30518]=1; image[30519]=1; image[30520]=1; image[30521]=1; image[30522]=2; image[30523]=2; image[30524]=3; image[30525]=6; image[30526]=6; image[30527]=7; image[30528]=8; image[30529]=8; image[30530]=7; image[30531]=10; image[30532]=10; image[30533]=2; image[30534]=4; image[30535]=9; image[30536]=12; image[30537]=13; image[30538]=15; image[30539]=21; image[30540]=26; image[30541]=24; image[30542]=25; image[30543]=25; image[30544]=21; image[30545]=24; image[30546]=24; image[30547]=27; image[30548]=24; image[30549]=22; image[30550]=22; image[30551]=14; image[30552]=7; image[30553]=4; image[30554]=5; image[30555]=7; image[30556]=9; image[30557]=8; image[30558]=11; image[30559]=23; image[30560]=23; image[30561]=25; image[30562]=37; image[30563]=41; image[30564]=31; image[30565]=42; image[30566]=49; image[30567]=46; image[30568]=50; image[30569]=79; image[30570]=33; image[30571]=2; image[30572]=2; image[30573]=10; image[30574]=38; image[30575]=40; image[30576]=91; image[30577]=182; image[30578]=208; image[30579]=114; image[30580]=52; image[30581]=59; image[30582]=67; image[30583]=73; image[30584]=76; image[30585]=75; image[30586]=77; image[30587]=104; image[30588]=59; image[30589]=38; image[30590]=71; image[30591]=97; image[30592]=60; image[30593]=85; image[30594]=118; image[30595]=137; image[30596]=212; image[30597]=237; image[30598]=176; image[30599]=167; image[30600]=53; image[30601]=23; image[30602]=15; image[30603]=1; image[30604]=1; image[30605]=1; image[30606]=1; image[30607]=1; image[30608]=1; image[30609]=1; image[30610]=1; image[30611]=1; image[30612]=1; image[30613]=1; image[30614]=1; image[30615]=1; image[30616]=1; image[30617]=1; image[30618]=1; image[30619]=1; image[30620]=1; image[30621]=1; image[30622]=1; image[30623]=1; image[30624]=1; image[30625]=1; image[30626]=1; image[30627]=1; image[30628]=1; image[30629]=1; image[30630]=1; image[30631]=1; image[30632]=1; image[30633]=1; image[30634]=1; image[30635]=1; image[30636]=1; image[30637]=1; image[30638]=1; image[30639]=1; image[30640]=1; image[30641]=1; image[30642]=1; image[30643]=1; image[30644]=1; image[30645]=1; image[30646]=1; image[30647]=1; image[30648]=1; image[30649]=1; image[30650]=1; image[30651]=1; image[30652]=1; image[30653]=1; image[30654]=1; image[30655]=1; image[30656]=1; image[30657]=1; image[30658]=1; image[30659]=1; image[30660]=1; image[30661]=1; image[30662]=1; image[30663]=1; image[30664]=1; image[30665]=1; image[30666]=1; image[30667]=1; image[30668]=1; image[30669]=1; image[30670]=1; image[30671]=1; image[30672]=1; image[30673]=1; image[30674]=1; image[30675]=1; image[30676]=1; image[30677]=1; image[30678]=1; image[30679]=1; image[30680]=1; image[30681]=1; image[30682]=1; image[30683]=1; image[30684]=1; image[30685]=1; image[30686]=1; image[30687]=1; image[30688]=1; image[30689]=1; image[30690]=1; image[30691]=1; image[30692]=1; image[30693]=1; image[30694]=1; image[30695]=1; image[30696]=1; image[30697]=1; image[30698]=1; image[30699]=1; image[30700]=1; image[30701]=1; image[30702]=1; image[30703]=1; image[30704]=1; image[30705]=1; image[30706]=1; image[30707]=1; image[30708]=1; image[30709]=1; image[30710]=1; image[30711]=1; image[30712]=1; image[30713]=1; image[30714]=1; image[30715]=1; image[30716]=1; image[30717]=1; image[30718]=1; image[30719]=1; image[30720]=1; image[30721]=1; image[30722]=2; image[30723]=3; image[30724]=5; image[30725]=6; image[30726]=8; image[30727]=8; image[30728]=8; image[30729]=8; image[30730]=11; image[30731]=9; image[30732]=2; image[30733]=2; image[30734]=2; image[30735]=4; image[30736]=6; image[30737]=9; image[30738]=17; image[30739]=21; image[30740]=24; image[30741]=25; image[30742]=22; image[30743]=19; image[30744]=25; image[30745]=28; image[30746]=29; image[30747]=29; image[30748]=29; image[30749]=38; image[30750]=38; image[30751]=31; image[30752]=23; image[30753]=13; image[30754]=8; image[30755]=4; image[30756]=4; image[30757]=15; image[30758]=25; image[30759]=23; image[30760]=20; image[30761]=32; image[30762]=37; image[30763]=34; image[30764]=42; image[30765]=49; image[30766]=45; image[30767]=53; image[30768]=73; image[30769]=24; image[30770]=3; image[30771]=2; image[30772]=6; image[30773]=27; image[30774]=24; image[30775]=26; image[30776]=57; image[30777]=104; image[30778]=71; image[30779]=45; image[30780]=59; image[30781]=65; image[30782]=66; image[30783]=69; image[30784]=78; image[30785]=81; image[30786]=101; image[30787]=61; image[30788]=52; image[30789]=68; image[30790]=76; image[30791]=67; image[30792]=95; image[30793]=126; image[30794]=150; image[30795]=224; image[30796]=255; image[30797]=226; image[30798]=156; image[30799]=37; image[30800]=16; image[30801]=13; image[30802]=1; image[30803]=1; image[30804]=1; image[30805]=1; image[30806]=1; image[30807]=1; image[30808]=1; image[30809]=1; image[30810]=1; image[30811]=1; image[30812]=1; image[30813]=1; image[30814]=1; image[30815]=1; image[30816]=1; image[30817]=1; image[30818]=1; image[30819]=1; image[30820]=1; image[30821]=1; image[30822]=1; image[30823]=1; image[30824]=1; image[30825]=1; image[30826]=1; image[30827]=1; image[30828]=1; image[30829]=1; image[30830]=1; image[30831]=1; image[30832]=1; image[30833]=1; image[30834]=1; image[30835]=1; image[30836]=1; image[30837]=1; image[30838]=1; image[30839]=1; image[30840]=1; image[30841]=1; image[30842]=1; image[30843]=1; image[30844]=1; image[30845]=1; image[30846]=1; image[30847]=1; image[30848]=1; image[30849]=1; image[30850]=1; image[30851]=1; image[30852]=1; image[30853]=1; image[30854]=1; image[30855]=1; image[30856]=1; image[30857]=1; image[30858]=1; image[30859]=1; image[30860]=1; image[30861]=1; image[30862]=1; image[30863]=1; image[30864]=1; image[30865]=1; image[30866]=1; image[30867]=1; image[30868]=1; image[30869]=1; image[30870]=1; image[30871]=1; image[30872]=1; image[30873]=1; image[30874]=1; image[30875]=1; image[30876]=1; image[30877]=1; image[30878]=1; image[30879]=1; image[30880]=1; image[30881]=1; image[30882]=1; image[30883]=1; image[30884]=1; image[30885]=1; image[30886]=1; image[30887]=1; image[30888]=1; image[30889]=1; image[30890]=1; image[30891]=1; image[30892]=1; image[30893]=1; image[30894]=1; image[30895]=1; image[30896]=1; image[30897]=1; image[30898]=1; image[30899]=1; image[30900]=1; image[30901]=1; image[30902]=1; image[30903]=1; image[30904]=1; image[30905]=1; image[30906]=1; image[30907]=1; image[30908]=1; image[30909]=1; image[30910]=1; image[30911]=1; image[30912]=1; image[30913]=1; image[30914]=1; image[30915]=1; image[30916]=1; image[30917]=1; image[30918]=1; image[30919]=1; image[30920]=1; image[30921]=2; image[30922]=4; image[30923]=5; image[30924]=6; image[30925]=8; image[30926]=8; image[30927]=8; image[30928]=8; image[30929]=12; image[30930]=9; image[30931]=1; image[30932]=2; image[30933]=2; image[30934]=2; image[30935]=1; image[30936]=2; image[30937]=4; image[30938]=7; image[30939]=11; image[30940]=16; image[30941]=19; image[30942]=27; image[30943]=30; image[30944]=34; image[30945]=31; image[30946]=29; image[30947]=29; image[30948]=32; image[30949]=33; image[30950]=32; image[30951]=32; image[30952]=24; image[30953]=14; image[30954]=7; image[30955]=6; image[30956]=16; image[30957]=27; image[30958]=25; image[30959]=19; image[30960]=34; image[30961]=37; image[30962]=40; image[30963]=43; image[30964]=42; image[30965]=48; image[30966]=59; image[30967]=59; image[30968]=13; image[30969]=3; image[30970]=3; image[30971]=4; image[30972]=21; image[30973]=33; image[30974]=34; image[30975]=59; image[30976]=71; image[30977]=49; image[30978]=47; image[30979]=59; image[30980]=65; image[30981]=71; image[30982]=75; image[30983]=78; image[30984]=80; image[30985]=77; image[30986]=47; image[30987]=55; image[30988]=79; image[30989]=80; image[30990]=80; image[30991]=104; image[30992]=117; image[30993]=138; image[30994]=182; image[30995]=239; image[30996]=234; image[30997]=141; image[30998]=40; image[30999]=17; image[31000]=10; image[31001]=1; image[31002]=1; image[31003]=1; image[31004]=1; image[31005]=1; image[31006]=1; image[31007]=1; image[31008]=1; image[31009]=1; image[31010]=1; image[31011]=1; image[31012]=1; image[31013]=1; image[31014]=1; image[31015]=1; image[31016]=1; image[31017]=1; image[31018]=1; image[31019]=1; image[31020]=1; image[31021]=1; image[31022]=1; image[31023]=1; image[31024]=1; image[31025]=1; image[31026]=1; image[31027]=1; image[31028]=1; image[31029]=1; image[31030]=1; image[31031]=1; image[31032]=1; image[31033]=1; image[31034]=1; image[31035]=1; image[31036]=1; image[31037]=1; image[31038]=1; image[31039]=1; image[31040]=1; image[31041]=1; image[31042]=1; image[31043]=1; image[31044]=1; image[31045]=1; image[31046]=1; image[31047]=1; image[31048]=1; image[31049]=1; image[31050]=1; image[31051]=1; image[31052]=1; image[31053]=1; image[31054]=1; image[31055]=1; image[31056]=1; image[31057]=1; image[31058]=1; image[31059]=1; image[31060]=1; image[31061]=1; image[31062]=1; image[31063]=1; image[31064]=1; image[31065]=1; image[31066]=1; image[31067]=1; image[31068]=1; image[31069]=1; image[31070]=1; image[31071]=1; image[31072]=1; image[31073]=1; image[31074]=1; image[31075]=1; image[31076]=1; image[31077]=1; image[31078]=1; image[31079]=1; image[31080]=1; image[31081]=1; image[31082]=1; image[31083]=1; image[31084]=1; image[31085]=1; image[31086]=1; image[31087]=1; image[31088]=1; image[31089]=1; image[31090]=1; image[31091]=1; image[31092]=1; image[31093]=1; image[31094]=1; image[31095]=1; image[31096]=1; image[31097]=1; image[31098]=1; image[31099]=1; image[31100]=1; image[31101]=1; image[31102]=1; image[31103]=1; image[31104]=1; image[31105]=1; image[31106]=1; image[31107]=1; image[31108]=1; image[31109]=1; image[31110]=1; image[31111]=1; image[31112]=1; image[31113]=1; image[31114]=1; image[31115]=1; image[31116]=1; image[31117]=1; image[31118]=1; image[31119]=1; image[31120]=2; image[31121]=3; image[31122]=4; image[31123]=6; image[31124]=8; image[31125]=9; image[31126]=8; image[31127]=8; image[31128]=13; image[31129]=9; image[31130]=2; image[31131]=3; image[31132]=3; image[31133]=6; image[31134]=8; image[31135]=8; image[31136]=8; image[31137]=8; image[31138]=5; image[31139]=4; image[31140]=4; image[31141]=10; image[31142]=14; image[31143]=19; image[31144]=22; image[31145]=24; image[31146]=25; image[31147]=31; image[31148]=30; image[31149]=23; image[31150]=19; image[31151]=12; image[31152]=7; image[31153]=5; image[31154]=5; image[31155]=17; image[31156]=27; image[31157]=22; image[31158]=21; image[31159]=37; image[31160]=33; image[31161]=37; image[31162]=43; image[31163]=44; image[31164]=48; image[31165]=57; image[31166]=62; image[31167]=15; image[31168]=3; image[31169]=5; image[31170]=5; image[31171]=12; image[31172]=33; image[31173]=35; image[31174]=50; image[31175]=59; image[31176]=49; image[31177]=49; image[31178]=58; image[31179]=60; image[31180]=70; image[31181]=88; image[31182]=76; image[31183]=80; image[31184]=68; image[31185]=50; image[31186]=64; image[31187]=88; image[31188]=80; image[31189]=88; image[31190]=113; image[31191]=112; image[31192]=136; image[31193]=189; image[31194]=217; image[31195]=228; image[31196]=132; image[31197]=36; image[31198]=18; image[31199]=11; image[31200]=1; image[31201]=1; image[31202]=1; image[31203]=1; image[31204]=1; image[31205]=1; image[31206]=1; image[31207]=1; image[31208]=1; image[31209]=1; image[31210]=1; image[31211]=1; image[31212]=1; image[31213]=1; image[31214]=1; image[31215]=1; image[31216]=1; image[31217]=1; image[31218]=1; image[31219]=1; image[31220]=1; image[31221]=1; image[31222]=1; image[31223]=1; image[31224]=1; image[31225]=1; image[31226]=1; image[31227]=1; image[31228]=1; image[31229]=1; image[31230]=1; image[31231]=1; image[31232]=1; image[31233]=1; image[31234]=1; image[31235]=1; image[31236]=1; image[31237]=1; image[31238]=1; image[31239]=1; image[31240]=1; image[31241]=1; image[31242]=1; image[31243]=1; image[31244]=1; image[31245]=1; image[31246]=1; image[31247]=1; image[31248]=1; image[31249]=1; image[31250]=1; image[31251]=1; image[31252]=1; image[31253]=1; image[31254]=1; image[31255]=1; image[31256]=1; image[31257]=1; image[31258]=1; image[31259]=1; image[31260]=1; image[31261]=1; image[31262]=1; image[31263]=1; image[31264]=1; image[31265]=1; image[31266]=1; image[31267]=1; image[31268]=1; image[31269]=1; image[31270]=1; image[31271]=1; image[31272]=1; image[31273]=1; image[31274]=1; image[31275]=1; image[31276]=1; image[31277]=1; image[31278]=1; image[31279]=1; image[31280]=1; image[31281]=1; image[31282]=1; image[31283]=1; image[31284]=1; image[31285]=1; image[31286]=1; image[31287]=1; image[31288]=1; image[31289]=1; image[31290]=1; image[31291]=1; image[31292]=1; image[31293]=1; image[31294]=1; image[31295]=1; image[31296]=1; image[31297]=1; image[31298]=1; image[31299]=1; image[31300]=1; image[31301]=1; image[31302]=1; image[31303]=1; image[31304]=1; image[31305]=1; image[31306]=1; image[31307]=1; image[31308]=1; image[31309]=1; image[31310]=1; image[31311]=1; image[31312]=1; image[31313]=1; image[31314]=1; image[31315]=1; image[31316]=1; image[31317]=1; image[31318]=1; image[31319]=2; image[31320]=3; image[31321]=4; image[31322]=6; image[31323]=7; image[31324]=8; image[31325]=8; image[31326]=8; image[31327]=15; image[31328]=9; image[31329]=5; image[31330]=7; image[31331]=8; image[31332]=13; image[31333]=16; image[31334]=18; image[31335]=18; image[31336]=19; image[31337]=22; image[31338]=19; image[31339]=18; image[31340]=11; image[31341]=9; image[31342]=9; image[31343]=7; image[31344]=5; image[31345]=5; image[31346]=5; image[31347]=6; image[31348]=4; image[31349]=3; image[31350]=3; image[31351]=2; image[31352]=2; image[31353]=4; image[31354]=15; image[31355]=21; image[31356]=19; image[31357]=20; image[31358]=35; image[31359]=35; image[31360]=37; image[31361]=39; image[31362]=44; image[31363]=40; image[31364]=47; image[31365]=51; image[31366]=10; image[31367]=4; image[31368]=9; image[31369]=20; image[31370]=11; image[31371]=48; image[31372]=49; image[31373]=42; image[31374]=77; image[31375]=62; image[31376]=53; image[31377]=64; image[31378]=61; image[31379]=80; image[31380]=86; image[31381]=64; image[31382]=63; image[31383]=44; image[31384]=54; image[31385]=73; image[31386]=85; image[31387]=71; image[31388]=78; image[31389]=111; image[31390]=111; image[31391]=133; image[31392]=195; image[31393]=236; image[31394]=236; image[31395]=148; image[31396]=42; image[31397]=15; image[31398]=10; image[31399]=1; image[31400]=1; image[31401]=1; image[31402]=1; image[31403]=1; image[31404]=1; image[31405]=1; image[31406]=1; image[31407]=1; image[31408]=1; image[31409]=1; image[31410]=1; image[31411]=1; image[31412]=1; image[31413]=1; image[31414]=1; image[31415]=1; image[31416]=1; image[31417]=1; image[31418]=0; image[31419]=1; image[31420]=1; image[31421]=1; image[31422]=1; image[31423]=1; image[31424]=1; image[31425]=1; image[31426]=1; image[31427]=1; image[31428]=1; image[31429]=1; image[31430]=1; image[31431]=1; image[31432]=1; image[31433]=1; image[31434]=1; image[31435]=1; image[31436]=1; image[31437]=1; image[31438]=1; image[31439]=1; image[31440]=1; image[31441]=1; image[31442]=1; image[31443]=1; image[31444]=1; image[31445]=1; image[31446]=1; image[31447]=1; image[31448]=1; image[31449]=1; image[31450]=1; image[31451]=1; image[31452]=1; image[31453]=1; image[31454]=1; image[31455]=1; image[31456]=1; image[31457]=1; image[31458]=1; image[31459]=1; image[31460]=1; image[31461]=1; image[31462]=1; image[31463]=1; image[31464]=1; image[31465]=1; image[31466]=1; image[31467]=1; image[31468]=1; image[31469]=1; image[31470]=1; image[31471]=1; image[31472]=1; image[31473]=1; image[31474]=1; image[31475]=1; image[31476]=1; image[31477]=1; image[31478]=1; image[31479]=1; image[31480]=1; image[31481]=1; image[31482]=1; image[31483]=1; image[31484]=1; image[31485]=1; image[31486]=1; image[31487]=1; image[31488]=1; image[31489]=1; image[31490]=1; image[31491]=1; image[31492]=1; image[31493]=1; image[31494]=1; image[31495]=1; image[31496]=1; image[31497]=1; image[31498]=1; image[31499]=1; image[31500]=1; image[31501]=1; image[31502]=1; image[31503]=1; image[31504]=1; image[31505]=1; image[31506]=1; image[31507]=1; image[31508]=1; image[31509]=1; image[31510]=1; image[31511]=1; image[31512]=1; image[31513]=1; image[31514]=1; image[31515]=1; image[31516]=1; image[31517]=1; image[31518]=1; image[31519]=2; image[31520]=4; image[31521]=7; image[31522]=7; image[31523]=8; image[31524]=9; image[31525]=9; image[31526]=13; image[31527]=6; image[31528]=6; image[31529]=10; image[31530]=12; image[31531]=15; image[31532]=16; image[31533]=17; image[31534]=15; image[31535]=16; image[31536]=19; image[31537]=19; image[31538]=21; image[31539]=26; image[31540]=27; image[31541]=26; image[31542]=26; image[31543]=22; image[31544]=19; image[31545]=16; image[31546]=14; image[31547]=11; image[31548]=9; image[31549]=9; image[31550]=10; image[31551]=13; image[31552]=6; image[31553]=15; image[31554]=21; image[31555]=18; image[31556]=22; image[31557]=34; image[31558]=30; image[31559]=34; image[31560]=42; image[31561]=48; image[31562]=42; image[31563]=40; image[31564]=29; image[31565]=7; image[31566]=5; image[31567]=14; image[31568]=54; image[31569]=37; image[31570]=52; image[31571]=89; image[31572]=82; image[31573]=61; image[31574]=58; image[31575]=51; image[31576]=60; image[31577]=68; image[31578]=86; image[31579]=69; image[31580]=58; image[31581]=61; image[31582]=46; image[31583]=57; image[31584]=80; image[31585]=89; image[31586]=79; image[31587]=75; image[31588]=114; image[31589]=124; image[31590]=131; image[31591]=171; image[31592]=217; image[31593]=246; image[31594]=139; image[31595]=31; image[31596]=16; image[31597]=8; image[31598]=1; image[31599]=1; image[31600]=1; image[31601]=1; image[31602]=1; image[31603]=1; image[31604]=1; image[31605]=1; image[31606]=1; image[31607]=1; image[31608]=1; image[31609]=1; image[31610]=1; image[31611]=1; image[31612]=1; image[31613]=1; image[31614]=1; image[31615]=1; image[31616]=1; image[31617]=1; image[31618]=1; image[31619]=1; image[31620]=1; image[31621]=1; image[31622]=1; image[31623]=1; image[31624]=1; image[31625]=1; image[31626]=1; image[31627]=1; image[31628]=1; image[31629]=1; image[31630]=1; image[31631]=1; image[31632]=1; image[31633]=1; image[31634]=1; image[31635]=1; image[31636]=1; image[31637]=1; image[31638]=1; image[31639]=1; image[31640]=1; image[31641]=1; image[31642]=1; image[31643]=1; image[31644]=1; image[31645]=1; image[31646]=1; image[31647]=1; image[31648]=1; image[31649]=1; image[31650]=1; image[31651]=1; image[31652]=1; image[31653]=1; image[31654]=1; image[31655]=1; image[31656]=1; image[31657]=1; image[31658]=1; image[31659]=1; image[31660]=1; image[31661]=1; image[31662]=1; image[31663]=1; image[31664]=1; image[31665]=1; image[31666]=1; image[31667]=1; image[31668]=1; image[31669]=1; image[31670]=1; image[31671]=1; image[31672]=1; image[31673]=1; image[31674]=1; image[31675]=1; image[31676]=1; image[31677]=1; image[31678]=1; image[31679]=1; image[31680]=1; image[31681]=1; image[31682]=1; image[31683]=1; image[31684]=1; image[31685]=1; image[31686]=1; image[31687]=1; image[31688]=1; image[31689]=1; image[31690]=1; image[31691]=1; image[31692]=1; image[31693]=1; image[31694]=1; image[31695]=1; image[31696]=1; image[31697]=1; image[31698]=1; image[31699]=1; image[31700]=1; image[31701]=1; image[31702]=1; image[31703]=1; image[31704]=1; image[31705]=1; image[31706]=1; image[31707]=1; image[31708]=1; image[31709]=1; image[31710]=1; image[31711]=1; image[31712]=1; image[31713]=1; image[31714]=1; image[31715]=1; image[31716]=1; image[31717]=1; image[31718]=2; image[31719]=4; image[31720]=6; image[31721]=8; image[31722]=7; image[31723]=8; image[31724]=11; image[31725]=12; image[31726]=5; image[31727]=5; image[31728]=9; image[31729]=12; image[31730]=15; image[31731]=16; image[31732]=16; image[31733]=17; image[31734]=17; image[31735]=17; image[31736]=18; image[31737]=19; image[31738]=21; image[31739]=21; image[31740]=20; image[31741]=27; image[31742]=29; image[31743]=30; image[31744]=31; image[31745]=30; image[31746]=31; image[31747]=20; image[31748]=14; image[31749]=19; image[31750]=19; image[31751]=6; image[31752]=14; image[31753]=23; image[31754]=18; image[31755]=23; image[31756]=32; image[31757]=29; image[31758]=33; image[31759]=43; image[31760]=45; image[31761]=40; image[31762]=36; image[31763]=21; image[31764]=7; image[31765]=6; image[31766]=18; image[31767]=95; image[31768]=76; image[31769]=36; image[31770]=62; image[31771]=106; image[31772]=62; image[31773]=55; image[31774]=55; image[31775]=58; image[31776]=69; image[31777]=77; image[31778]=58; image[31779]=57; image[31780]=51; image[31781]=44; image[31782]=64; image[31783]=89; image[31784]=93; image[31785]=91; image[31786]=76; image[31787]=114; image[31788]=147; image[31789]=141; image[31790]=155; image[31791]=174; image[31792]=247; image[31793]=180; image[31794]=32; image[31795]=16; image[31796]=8; image[31797]=1; image[31798]=1; image[31799]=1; image[31800]=1; image[31801]=1; image[31802]=1; image[31803]=1; image[31804]=1; image[31805]=1; image[31806]=1; image[31807]=1; image[31808]=1; image[31809]=1; image[31810]=1; image[31811]=1; image[31812]=1; image[31813]=1; image[31814]=1; image[31815]=1; image[31816]=1; image[31817]=1; image[31818]=1; image[31819]=1; image[31820]=1; image[31821]=1; image[31822]=1; image[31823]=1; image[31824]=1; image[31825]=1; image[31826]=1; image[31827]=1; image[31828]=1; image[31829]=1; image[31830]=1; image[31831]=1; image[31832]=1; image[31833]=1; image[31834]=1; image[31835]=1; image[31836]=1; image[31837]=1; image[31838]=1; image[31839]=1; image[31840]=1; image[31841]=1; image[31842]=1; image[31843]=1; image[31844]=1; image[31845]=1; image[31846]=1; image[31847]=1; image[31848]=1; image[31849]=1; image[31850]=1; image[31851]=1; image[31852]=1; image[31853]=1; image[31854]=1; image[31855]=1; image[31856]=1; image[31857]=1; image[31858]=1; image[31859]=1; image[31860]=1; image[31861]=1; image[31862]=1; image[31863]=1; image[31864]=1; image[31865]=1; image[31866]=1; image[31867]=1; image[31868]=1; image[31869]=1; image[31870]=1; image[31871]=1; image[31872]=1; image[31873]=1; image[31874]=1; image[31875]=1; image[31876]=1; image[31877]=1; image[31878]=1; image[31879]=1; image[31880]=1; image[31881]=1; image[31882]=1; image[31883]=1; image[31884]=1; image[31885]=1; image[31886]=1; image[31887]=1; image[31888]=1; image[31889]=1; image[31890]=1; image[31891]=1; image[31892]=1; image[31893]=1; image[31894]=1; image[31895]=1; image[31896]=1; image[31897]=1; image[31898]=1; image[31899]=1; image[31900]=1; image[31901]=1; image[31902]=1; image[31903]=1; image[31904]=1; image[31905]=1; image[31906]=1; image[31907]=1; image[31908]=1; image[31909]=1; image[31910]=1; image[31911]=1; image[31912]=1; image[31913]=1; image[31914]=1; image[31915]=1; image[31916]=2; image[31917]=3; image[31918]=4; image[31919]=6; image[31920]=9; image[31921]=8; image[31922]=7; image[31923]=12; image[31924]=11; image[31925]=5; image[31926]=5; image[31927]=8; image[31928]=12; image[31929]=13; image[31930]=14; image[31931]=15; image[31932]=16; image[31933]=16; image[31934]=19; image[31935]=18; image[31936]=19; image[31937]=20; image[31938]=23; image[31939]=24; image[31940]=23; image[31941]=24; image[31942]=27; image[31943]=30; image[31944]=30; image[31945]=35; image[31946]=28; image[31947]=16; image[31948]=23; image[31949]=22; image[31950]=10; image[31951]=14; image[31952]=24; image[31953]=20; image[31954]=24; image[31955]=32; image[31956]=31; image[31957]=33; image[31958]=43; image[31959]=47; image[31960]=41; image[31961]=34; image[31962]=16; image[31963]=6; image[31964]=9; image[31965]=27; image[31966]=133; image[31967]=122; image[31968]=57; image[31969]=56; image[31970]=79; image[31971]=83; image[31972]=57; image[31973]=56; image[31974]=57; image[31975]=68; image[31976]=72; image[31977]=59; image[31978]=56; image[31979]=43; image[31980]=48; image[31981]=75; image[31982]=84; image[31983]=84; image[31984]=91; image[31985]=76; image[31986]=120; image[31987]=166; image[31988]=141; image[31989]=156; image[31990]=149; image[31991]=215; image[31992]=189; image[31993]=36; image[31994]=18; image[31995]=8; image[31996]=1; image[31997]=1; image[31998]=1; image[31999]=1; image[32000]=1; image[32001]=1; image[32002]=1; image[32003]=1; image[32004]=1; image[32005]=1; image[32006]=1; image[32007]=1; image[32008]=1; image[32009]=1; image[32010]=1; image[32011]=1; image[32012]=1; image[32013]=1; image[32014]=1; image[32015]=1; image[32016]=1; image[32017]=1; image[32018]=1; image[32019]=1; image[32020]=1; image[32021]=1; image[32022]=1; image[32023]=1; image[32024]=1; image[32025]=1; image[32026]=1; image[32027]=1; image[32028]=1; image[32029]=1; image[32030]=1; image[32031]=1; image[32032]=1; image[32033]=1; image[32034]=1; image[32035]=1; image[32036]=1; image[32037]=1; image[32038]=1; image[32039]=1; image[32040]=1; image[32041]=1; image[32042]=1; image[32043]=1; image[32044]=1; image[32045]=1; image[32046]=1; image[32047]=1; image[32048]=1; image[32049]=1; image[32050]=1; image[32051]=1; image[32052]=1; image[32053]=1; image[32054]=1; image[32055]=1; image[32056]=1; image[32057]=1; image[32058]=1; image[32059]=1; image[32060]=1; image[32061]=1; image[32062]=1; image[32063]=1; image[32064]=1; image[32065]=1; image[32066]=1; image[32067]=1; image[32068]=1; image[32069]=1; image[32070]=1; image[32071]=1; image[32072]=1; image[32073]=1; image[32074]=1; image[32075]=1; image[32076]=1; image[32077]=1; image[32078]=1; image[32079]=1; image[32080]=1; image[32081]=1; image[32082]=1; image[32083]=1; image[32084]=1; image[32085]=1; image[32086]=1; image[32087]=1; image[32088]=1; image[32089]=1; image[32090]=1; image[32091]=1; image[32092]=1; image[32093]=1; image[32094]=1; image[32095]=1; image[32096]=1; image[32097]=1; image[32098]=1; image[32099]=1; image[32100]=1; image[32101]=1; image[32102]=1; image[32103]=1; image[32104]=1; image[32105]=1; image[32106]=1; image[32107]=1; image[32108]=1; image[32109]=1; image[32110]=1; image[32111]=1; image[32112]=1; image[32113]=1; image[32114]=1; image[32115]=2; image[32116]=2; image[32117]=4; image[32118]=7; image[32119]=8; image[32120]=7; image[32121]=7; image[32122]=14; image[32123]=9; image[32124]=4; image[32125]=3; image[32126]=7; image[32127]=10; image[32128]=12; image[32129]=13; image[32130]=14; image[32131]=16; image[32132]=16; image[32133]=17; image[32134]=19; image[32135]=22; image[32136]=21; image[32137]=21; image[32138]=22; image[32139]=22; image[32140]=27; image[32141]=28; image[32142]=25; image[32143]=26; image[32144]=29; image[32145]=32; image[32146]=20; image[32147]=23; image[32148]=18; image[32149]=7; image[32150]=14; image[32151]=26; image[32152]=21; image[32153]=26; image[32154]=35; image[32155]=31; image[32156]=38; image[32157]=43; image[32158]=43; image[32159]=39; image[32160]=32; image[32161]=11; image[32162]=6; image[32163]=10; image[32164]=41; image[32165]=161; image[32166]=137; image[32167]=52; image[32168]=62; image[32169]=64; image[32170]=80; image[32171]=59; image[32172]=55; image[32173]=59; image[32174]=67; image[32175]=64; image[32176]=64; image[32177]=59; image[32178]=41; image[32179]=50; image[32180]=76; image[32181]=86; image[32182]=88; image[32183]=93; image[32184]=77; image[32185]=113; image[32186]=174; image[32187]=172; image[32188]=157; image[32189]=147; image[32190]=179; image[32191]=204; image[32192]=48; image[32193]=17; image[32194]=8; image[32195]=1; image[32196]=1; image[32197]=1; image[32198]=1; image[32199]=1; image[32200]=1; image[32201]=1; image[32202]=1; image[32203]=1; image[32204]=1; image[32205]=1; image[32206]=1; image[32207]=1; image[32208]=1; image[32209]=1; image[32210]=1; image[32211]=1; image[32212]=1; image[32213]=1; image[32214]=1; image[32215]=1; image[32216]=1; image[32217]=1; image[32218]=1; image[32219]=1; image[32220]=1; image[32221]=1; image[32222]=1; image[32223]=1; image[32224]=1; image[32225]=1; image[32226]=1; image[32227]=1; image[32228]=1; image[32229]=1; image[32230]=1; image[32231]=1; image[32232]=1; image[32233]=1; image[32234]=1; image[32235]=1; image[32236]=1; image[32237]=1; image[32238]=1; image[32239]=1; image[32240]=1; image[32241]=1; image[32242]=1; image[32243]=1; image[32244]=1; image[32245]=1; image[32246]=1; image[32247]=1; image[32248]=1; image[32249]=1; image[32250]=1; image[32251]=1; image[32252]=1; image[32253]=1; image[32254]=1; image[32255]=1; image[32256]=1; image[32257]=1; image[32258]=1; image[32259]=1; image[32260]=1; image[32261]=1; image[32262]=1; image[32263]=1; image[32264]=1; image[32265]=1; image[32266]=1; image[32267]=1; image[32268]=1; image[32269]=1; image[32270]=1; image[32271]=1; image[32272]=1; image[32273]=1; image[32274]=1; image[32275]=1; image[32276]=1; image[32277]=1; image[32278]=1; image[32279]=1; image[32280]=1; image[32281]=1; image[32282]=1; image[32283]=1; image[32284]=1; image[32285]=1; image[32286]=1; image[32287]=1; image[32288]=1; image[32289]=1; image[32290]=1; image[32291]=1; image[32292]=1; image[32293]=1; image[32294]=1; image[32295]=1; image[32296]=1; image[32297]=1; image[32298]=1; image[32299]=1; image[32300]=1; image[32301]=1; image[32302]=1; image[32303]=1; image[32304]=1; image[32305]=1; image[32306]=1; image[32307]=1; image[32308]=1; image[32309]=1; image[32310]=1; image[32311]=1; image[32312]=1; image[32313]=1; image[32314]=2; image[32315]=2; image[32316]=4; image[32317]=7; image[32318]=7; image[32319]=7; image[32320]=8; image[32321]=15; image[32322]=8; image[32323]=5; image[32324]=3; image[32325]=6; image[32326]=10; image[32327]=13; image[32328]=14; image[32329]=15; image[32330]=16; image[32331]=15; image[32332]=16; image[32333]=18; image[32334]=19; image[32335]=20; image[32336]=22; image[32337]=23; image[32338]=21; image[32339]=26; image[32340]=28; image[32341]=26; image[32342]=30; image[32343]=30; image[32344]=31; image[32345]=26; image[32346]=24; image[32347]=15; image[32348]=8; image[32349]=15; image[32350]=24; image[32351]=22; image[32352]=27; image[32353]=34; image[32354]=31; image[32355]=40; image[32356]=42; image[32357]=38; image[32358]=41; image[32359]=30; image[32360]=6; image[32361]=5; image[32362]=10; image[32363]=35; image[32364]=106; image[32365]=101; image[32366]=48; image[32367]=59; image[32368]=67; image[32369]=74; image[32370]=57; image[32371]=53; image[32372]=60; image[32373]=60; image[32374]=61; image[32375]=63; image[32376]=52; image[32377]=41; image[32378]=52; image[32379]=76; image[32380]=95; image[32381]=99; image[32382]=96; image[32383]=81; image[32384]=108; image[32385]=152; image[32386]=215; image[32387]=228; image[32388]=219; image[32389]=129; image[32390]=165; image[32391]=51; image[32392]=17; image[32393]=9; image[32394]=2; image[32395]=1; image[32396]=1; image[32397]=1; image[32398]=1; image[32399]=1; image[32400]=1; image[32401]=1; image[32402]=1; image[32403]=1; image[32404]=1; image[32405]=1; image[32406]=1; image[32407]=1; image[32408]=1; image[32409]=1; image[32410]=1; image[32411]=1; image[32412]=1; image[32413]=1; image[32414]=1; image[32415]=1; image[32416]=1; image[32417]=1; image[32418]=1; image[32419]=1; image[32420]=1; image[32421]=1; image[32422]=1; image[32423]=1; image[32424]=1; image[32425]=1; image[32426]=1; image[32427]=1; image[32428]=1; image[32429]=1; image[32430]=1; image[32431]=1; image[32432]=1; image[32433]=1; image[32434]=1; image[32435]=1; image[32436]=1; image[32437]=1; image[32438]=1; image[32439]=1; image[32440]=1; image[32441]=1; image[32442]=1; image[32443]=1; image[32444]=1; image[32445]=1; image[32446]=1; image[32447]=1; image[32448]=1; image[32449]=1; image[32450]=1; image[32451]=1; image[32452]=1; image[32453]=1; image[32454]=1; image[32455]=1; image[32456]=1; image[32457]=1; image[32458]=1; image[32459]=1; image[32460]=1; image[32461]=1; image[32462]=1; image[32463]=1; image[32464]=1; image[32465]=1; image[32466]=1; image[32467]=1; image[32468]=1; image[32469]=1; image[32470]=1; image[32471]=1; image[32472]=1; image[32473]=1; image[32474]=1; image[32475]=1; image[32476]=1; image[32477]=1; image[32478]=1; image[32479]=1; image[32480]=1; image[32481]=1; image[32482]=1; image[32483]=1; image[32484]=1; image[32485]=1; image[32486]=1; image[32487]=1; image[32488]=1; image[32489]=1; image[32490]=1; image[32491]=1; image[32492]=1; image[32493]=1; image[32494]=1; image[32495]=1; image[32496]=1; image[32497]=1; image[32498]=1; image[32499]=1; image[32500]=1; image[32501]=1; image[32502]=1; image[32503]=1; image[32504]=1; image[32505]=1; image[32506]=1; image[32507]=1; image[32508]=1; image[32509]=1; image[32510]=1; image[32511]=1; image[32512]=1; image[32513]=2; image[32514]=2; image[32515]=4; image[32516]=6; image[32517]=7; image[32518]=8; image[32519]=8; image[32520]=10; image[32521]=6; image[32522]=4; image[32523]=3; image[32524]=7; image[32525]=11; image[32526]=15; image[32527]=17; image[32528]=15; image[32529]=16; image[32530]=15; image[32531]=19; image[32532]=18; image[32533]=17; image[32534]=19; image[32535]=21; image[32536]=22; image[32537]=21; image[32538]=24; image[32539]=24; image[32540]=27; image[32541]=28; image[32542]=31; image[32543]=31; image[32544]=29; image[32545]=24; image[32546]=16; image[32547]=10; image[32548]=17; image[32549]=23; image[32550]=22; image[32551]=29; image[32552]=35; image[32553]=35; image[32554]=36; image[32555]=37; image[32556]=36; image[32557]=31; image[32558]=20; image[32559]=4; image[32560]=3; image[32561]=14; image[32562]=64; image[32563]=117; image[32564]=48; image[32565]=46; image[32566]=92; image[32567]=117; image[32568]=84; image[32569]=56; image[32570]=58; image[32571]=69; image[32572]=72; image[32573]=73; image[32574]=65; image[32575]=52; image[32576]=43; image[32577]=58; image[32578]=81; image[32579]=86; image[32580]=94; image[32581]=95; image[32582]=81; image[32583]=114; image[32584]=134; image[32585]=182; image[32586]=253; image[32587]=249; image[32588]=153; image[32589]=167; image[32590]=54; image[32591]=17; image[32592]=11; image[32593]=2; image[32594]=1; image[32595]=1; image[32596]=1; image[32597]=1; image[32598]=1; image[32599]=1; image[32600]=1; image[32601]=1; image[32602]=1; image[32603]=1; image[32604]=1; image[32605]=1; image[32606]=1; image[32607]=1; image[32608]=1; image[32609]=1; image[32610]=1; image[32611]=1; image[32612]=1; image[32613]=1; image[32614]=1; image[32615]=1; image[32616]=1; image[32617]=1; image[32618]=1; image[32619]=1; image[32620]=1; image[32621]=1; image[32622]=1; image[32623]=1; image[32624]=1; image[32625]=1; image[32626]=1; image[32627]=1; image[32628]=1; image[32629]=1; image[32630]=1; image[32631]=1; image[32632]=1; image[32633]=1; image[32634]=1; image[32635]=1; image[32636]=1; image[32637]=1; image[32638]=1; image[32639]=1; image[32640]=1; image[32641]=1; image[32642]=1; image[32643]=1; image[32644]=1; image[32645]=1; image[32646]=1; image[32647]=1; image[32648]=1; image[32649]=1; image[32650]=1; image[32651]=1; image[32652]=1; image[32653]=1; image[32654]=1; image[32655]=1; image[32656]=1; image[32657]=1; image[32658]=1; image[32659]=1; image[32660]=1; image[32661]=1; image[32662]=1; image[32663]=1; image[32664]=0; image[32665]=1; image[32666]=1; image[32667]=1; image[32668]=1; image[32669]=1; image[32670]=1; image[32671]=1; image[32672]=1; image[32673]=1; image[32674]=1; image[32675]=1; image[32676]=1; image[32677]=1; image[32678]=1; image[32679]=1; image[32680]=1; image[32681]=1; image[32682]=1; image[32683]=1; image[32684]=1; image[32685]=1; image[32686]=1; image[32687]=1; image[32688]=1; image[32689]=1; image[32690]=1; image[32691]=1; image[32692]=1; image[32693]=1; image[32694]=1; image[32695]=1; image[32696]=1; image[32697]=1; image[32698]=1; image[32699]=1; image[32700]=1; image[32701]=1; image[32702]=1; image[32703]=1; image[32704]=1; image[32705]=1; image[32706]=1; image[32707]=1; image[32708]=1; image[32709]=1; image[32710]=1; image[32711]=1; image[32712]=2; image[32713]=2; image[32714]=5; image[32715]=6; image[32716]=7; image[32717]=7; image[32718]=5; image[32719]=5; image[32720]=5; image[32721]=5; image[32722]=4; image[32723]=6; image[32724]=9; image[32725]=14; image[32726]=16; image[32727]=17; image[32728]=16; image[32729]=14; image[32730]=18; image[32731]=18; image[32732]=19; image[32733]=23; image[32734]=23; image[32735]=21; image[32736]=23; image[32737]=25; image[32738]=26; image[32739]=25; image[32740]=30; image[32741]=32; image[32742]=27; image[32743]=26; image[32744]=23; image[32745]=14; image[32746]=11; image[32747]=19; image[32748]=26; image[32749]=21; image[32750]=27; image[32751]=33; image[32752]=33; image[32753]=31; image[32754]=36; image[32755]=34; image[32756]=22; image[32757]=16; image[32758]=5; image[32759]=1; image[32760]=10; image[32761]=74; image[32762]=186; image[32763]=55; image[32764]=40; image[32765]=75; image[32766]=104; image[32767]=81; image[32768]=66; image[32769]=73; image[32770]=67; image[32771]=71; image[32772]=76; image[32773]=76; image[32774]=48; image[32775]=43; image[32776]=61; image[32777]=84; image[32778]=86; image[32779]=95; image[32780]=96; image[32781]=85; image[32782]=111; image[32783]=149; image[32784]=210; image[32785]=254; image[32786]=255; image[32787]=202; image[32788]=214; image[32789]=72; image[32790]=23; image[32791]=17; image[32792]=2; image[32793]=1; image[32794]=1; image[32795]=1; image[32796]=1; image[32797]=1; image[32798]=1; image[32799]=1; image[32800]=1; image[32801]=1; image[32802]=1; image[32803]=1; image[32804]=1; image[32805]=1; image[32806]=1; image[32807]=1; image[32808]=1; image[32809]=1; image[32810]=1; image[32811]=1; image[32812]=1; image[32813]=1; image[32814]=1; image[32815]=1; image[32816]=1; image[32817]=1; image[32818]=1; image[32819]=1; image[32820]=1; image[32821]=1; image[32822]=1; image[32823]=1; image[32824]=1; image[32825]=1; image[32826]=1; image[32827]=1; image[32828]=1; image[32829]=1; image[32830]=1; image[32831]=1; image[32832]=1; image[32833]=1; image[32834]=1; image[32835]=1; image[32836]=1; image[32837]=1; image[32838]=1; image[32839]=1; image[32840]=1; image[32841]=1; image[32842]=1; image[32843]=1; image[32844]=1; image[32845]=1; image[32846]=1; image[32847]=1; image[32848]=1; image[32849]=1; image[32850]=1; image[32851]=1; image[32852]=1; image[32853]=1; image[32854]=1; image[32855]=1; image[32856]=1; image[32857]=1; image[32858]=1; image[32859]=1; image[32860]=1; image[32861]=1; image[32862]=1; image[32863]=1; image[32864]=1; image[32865]=1; image[32866]=1; image[32867]=1; image[32868]=1; image[32869]=1; image[32870]=1; image[32871]=1; image[32872]=1; image[32873]=1; image[32874]=1; image[32875]=1; image[32876]=1; image[32877]=1; image[32878]=1; image[32879]=1; image[32880]=1; image[32881]=1; image[32882]=1; image[32883]=1; image[32884]=1; image[32885]=1; image[32886]=1; image[32887]=1; image[32888]=1; image[32889]=1; image[32890]=1; image[32891]=1; image[32892]=1; image[32893]=1; image[32894]=1; image[32895]=1; image[32896]=1; image[32897]=1; image[32898]=1; image[32899]=1; image[32900]=1; image[32901]=1; image[32902]=1; image[32903]=1; image[32904]=1; image[32905]=1; image[32906]=1; image[32907]=1; image[32908]=1; image[32909]=1; image[32910]=1; image[32911]=1; image[32912]=2; image[32913]=4; image[32914]=6; image[32915]=7; image[32916]=7; image[32917]=4; image[32918]=3; image[32919]=4; image[32920]=5; image[32921]=6; image[32922]=10; image[32923]=14; image[32924]=15; image[32925]=15; image[32926]=16; image[32927]=12; image[32928]=13; image[32929]=15; image[32930]=15; image[32931]=18; image[32932]=20; image[32933]=20; image[32934]=18; image[32935]=22; image[32936]=22; image[32937]=23; image[32938]=25; image[32939]=34; image[32940]=29; image[32941]=26; image[32942]=26; image[32943]=25; image[32944]=13; image[32945]=13; image[32946]=19; image[32947]=23; image[32948]=22; image[32949]=30; image[32950]=32; image[32951]=30; image[32952]=31; image[32953]=36; image[32954]=34; image[32955]=19; image[32956]=12; image[32957]=5; image[32958]=1; image[32959]=4; image[32960]=41; image[32961]=159; image[32962]=71; image[32963]=36; image[32964]=47; image[32965]=50; image[32966]=59; image[32967]=69; image[32968]=76; image[32969]=66; image[32970]=54; image[32971]=60; image[32972]=85; image[32973]=44; image[32974]=47; image[32975]=72; image[32976]=87; image[32977]=93; image[32978]=95; image[32979]=96; image[32980]=88; image[32981]=92; image[32982]=120; image[32983]=188; image[32984]=254; image[32985]=255; image[32986]=204; image[32987]=183; image[32988]=71; image[32989]=17; image[32990]=17; image[32991]=2; image[32992]=1; image[32993]=1; image[32994]=1; image[32995]=1; image[32996]=1; image[32997]=1; image[32998]=1; image[32999]=1; image[33000]=1; image[33001]=1; image[33002]=0; image[33003]=1; image[33004]=1; image[33005]=1; image[33006]=1; image[33007]=1; image[33008]=1; image[33009]=1; image[33010]=1; image[33011]=1; image[33012]=1; image[33013]=1; image[33014]=1; image[33015]=1; image[33016]=1; image[33017]=1; image[33018]=1; image[33019]=1; image[33020]=1; image[33021]=1; image[33022]=1; image[33023]=1; image[33024]=1; image[33025]=1; image[33026]=1; image[33027]=1; image[33028]=1; image[33029]=1; image[33030]=1; image[33031]=1; image[33032]=1; image[33033]=1; image[33034]=1; image[33035]=1; image[33036]=1; image[33037]=1; image[33038]=1; image[33039]=1; image[33040]=1; image[33041]=1; image[33042]=1; image[33043]=1; image[33044]=1; image[33045]=1; image[33046]=1; image[33047]=1; image[33048]=1; image[33049]=1; image[33050]=1; image[33051]=1; image[33052]=1; image[33053]=1; image[33054]=1; image[33055]=1; image[33056]=1; image[33057]=1; image[33058]=1; image[33059]=1; image[33060]=1; image[33061]=1; image[33062]=1; image[33063]=1; image[33064]=1; image[33065]=1; image[33066]=1; image[33067]=1; image[33068]=1; image[33069]=1; image[33070]=1; image[33071]=1; image[33072]=1; image[33073]=1; image[33074]=1; image[33075]=1; image[33076]=1; image[33077]=1; image[33078]=1; image[33079]=1; image[33080]=1; image[33081]=1; image[33082]=1; image[33083]=1; image[33084]=1; image[33085]=1; image[33086]=1; image[33087]=1; image[33088]=1; image[33089]=1; image[33090]=1; image[33091]=1; image[33092]=1; image[33093]=1; image[33094]=1; image[33095]=1; image[33096]=1; image[33097]=1; image[33098]=1; image[33099]=2; image[33100]=1; image[33101]=1; image[33102]=1; image[33103]=1; image[33104]=1; image[33105]=1; image[33106]=1; image[33107]=1; image[33108]=1; image[33109]=1; image[33110]=2; image[33111]=3; image[33112]=4; image[33113]=6; image[33114]=6; image[33115]=5; image[33116]=3; image[33117]=2; image[33118]=4; image[33119]=4; image[33120]=7; image[33121]=11; image[33122]=15; image[33123]=13; image[33124]=15; image[33125]=15; image[33126]=14; image[33127]=16; image[33128]=18; image[33129]=18; image[33130]=19; image[33131]=23; image[33132]=23; image[33133]=21; image[33134]=20; image[33135]=21; image[33136]=22; image[33137]=22; image[33138]=26; image[33139]=28; image[33140]=27; image[33141]=22; image[33142]=19; image[33143]=15; image[33144]=18; image[33145]=23; image[33146]=26; image[33147]=22; image[33148]=33; image[33149]=33; image[33150]=37; image[33151]=33; image[33152]=41; image[33153]=41; image[33154]=22; image[33155]=11; image[33156]=8; image[33157]=3; image[33158]=2; image[33159]=10; image[33160]=87; image[33161]=81; image[33162]=34; image[33163]=42; image[33164]=44; image[33165]=41; image[33166]=51; image[33167]=64; image[33168]=68; image[33169]=70; image[33170]=62; image[33171]=81; image[33172]=58; image[33173]=52; image[33174]=73; image[33175]=84; image[33176]=91; image[33177]=91; image[33178]=96; image[33179]=84; image[33180]=85; image[33181]=105; image[33182]=173; image[33183]=252; image[33184]=255; image[33185]=210; image[33186]=176; image[33187]=76; image[33188]=16; image[33189]=16; image[33190]=2; image[33191]=1; image[33192]=1; image[33193]=1; image[33194]=1; image[33195]=1; image[33196]=1; image[33197]=1; image[33198]=1; image[33199]=1; image[33200]=1; image[33201]=1; image[33202]=1; image[33203]=1; image[33204]=1; image[33205]=1; image[33206]=1; image[33207]=1; image[33208]=1; image[33209]=1; image[33210]=1; image[33211]=1; image[33212]=1; image[33213]=1; image[33214]=1; image[33215]=1; image[33216]=1; image[33217]=1; image[33218]=1; image[33219]=1; image[33220]=1; image[33221]=1; image[33222]=1; image[33223]=1; image[33224]=1; image[33225]=1; image[33226]=1; image[33227]=1; image[33228]=1; image[33229]=1; image[33230]=1; image[33231]=1; image[33232]=1; image[33233]=1; image[33234]=1; image[33235]=1; image[33236]=1; image[33237]=1; image[33238]=1; image[33239]=1; image[33240]=1; image[33241]=1; image[33242]=1; image[33243]=1; image[33244]=1; image[33245]=1; image[33246]=1; image[33247]=1; image[33248]=1; image[33249]=1; image[33250]=1; image[33251]=1; image[33252]=1; image[33253]=1; image[33254]=1; image[33255]=1; image[33256]=1; image[33257]=1; image[33258]=1; image[33259]=1; image[33260]=1; image[33261]=1; image[33262]=1; image[33263]=1; image[33264]=1; image[33265]=1; image[33266]=1; image[33267]=1; image[33268]=1; image[33269]=1; image[33270]=1; image[33271]=1; image[33272]=1; image[33273]=1; image[33274]=1; image[33275]=1; image[33276]=1; image[33277]=1; image[33278]=1; image[33279]=1; image[33280]=1; image[33281]=1; image[33282]=1; image[33283]=1; image[33284]=1; image[33285]=1; image[33286]=1; image[33287]=1; image[33288]=1; image[33289]=1; image[33290]=1; image[33291]=1; image[33292]=1; image[33293]=1; image[33294]=1; image[33295]=2; image[33296]=2; image[33297]=2; image[33298]=3; image[33299]=1; image[33300]=1; image[33301]=1; image[33302]=1; image[33303]=1; image[33304]=1; image[33305]=0; image[33306]=1; image[33307]=1; image[33308]=1; image[33309]=2; image[33310]=4; image[33311]=6; image[33312]=7; image[33313]=8; image[33314]=5; image[33315]=3; image[33316]=2; image[33317]=2; image[33318]=4; image[33319]=8; image[33320]=11; image[33321]=15; image[33322]=13; image[33323]=15; image[33324]=16; image[33325]=18; image[33326]=19; image[33327]=20; image[33328]=19; image[33329]=18; image[33330]=23; image[33331]=22; image[33332]=20; image[33333]=22; image[33334]=22; image[33335]=27; image[33336]=24; image[33337]=24; image[33338]=26; image[33339]=27; image[33340]=24; image[33341]=18; image[33342]=17; image[33343]=21; image[33344]=24; image[33345]=27; image[33346]=23; image[33347]=35; image[33348]=38; image[33349]=41; image[33350]=34; image[33351]=41; image[33352]=39; image[33353]=27; image[33354]=13; image[33355]=11; image[33356]=14; image[33357]=4; image[33358]=3; image[33359]=43; image[33360]=73; image[33361]=43; image[33362]=41; image[33363]=51; image[33364]=46; image[33365]=50; image[33366]=55; image[33367]=64; image[33368]=86; image[33369]=69; image[33370]=58; image[33371]=50; image[33372]=58; image[33373]=81; image[33374]=83; image[33375]=93; image[33376]=94; image[33377]=93; image[33378]=86; image[33379]=94; image[33380]=114; image[33381]=175; image[33382]=220; image[33383]=255; image[33384]=222; image[33385]=154; image[33386]=57; image[33387]=15; image[33388]=16; image[33389]=2; image[33390]=1; image[33391]=1; image[33392]=1; image[33393]=1; image[33394]=1; image[33395]=1; image[33396]=1; image[33397]=1; image[33398]=1; image[33399]=1; image[33400]=1; image[33401]=1; image[33402]=1; image[33403]=1; image[33404]=1; image[33405]=1; image[33406]=1; image[33407]=1; image[33408]=1; image[33409]=1; image[33410]=1; image[33411]=1; image[33412]=1; image[33413]=1; image[33414]=1; image[33415]=1; image[33416]=1; image[33417]=1; image[33418]=1; image[33419]=1; image[33420]=1; image[33421]=1; image[33422]=1; image[33423]=1; image[33424]=1; image[33425]=1; image[33426]=1; image[33427]=1; image[33428]=1; image[33429]=1; image[33430]=1; image[33431]=1; image[33432]=1; image[33433]=1; image[33434]=1; image[33435]=1; image[33436]=1; image[33437]=1; image[33438]=1; image[33439]=1; image[33440]=1; image[33441]=1; image[33442]=1; image[33443]=1; image[33444]=1; image[33445]=1; image[33446]=1; image[33447]=1; image[33448]=1; image[33449]=1; image[33450]=1; image[33451]=1; image[33452]=1; image[33453]=1; image[33454]=1; image[33455]=1; image[33456]=1; image[33457]=1; image[33458]=1; image[33459]=1; image[33460]=1; image[33461]=1; image[33462]=1; image[33463]=1; image[33464]=1; image[33465]=1; image[33466]=1; image[33467]=1; image[33468]=1; image[33469]=1; image[33470]=1; image[33471]=1; image[33472]=1; image[33473]=1; image[33474]=1; image[33475]=1; image[33476]=1; image[33477]=1; image[33478]=1; image[33479]=1; image[33480]=1; image[33481]=1; image[33482]=1; image[33483]=1; image[33484]=1; image[33485]=1; image[33486]=1; image[33487]=1; image[33488]=1; image[33489]=1; image[33490]=1; image[33491]=1; image[33492]=1; image[33493]=1; image[33494]=1; image[33495]=2; image[33496]=2; image[33497]=1; image[33498]=1; image[33499]=1; image[33500]=1; image[33501]=1; image[33502]=1; image[33503]=1; image[33504]=1; image[33505]=1; image[33506]=1; image[33507]=1; image[33508]=2; image[33509]=3; image[33510]=5; image[33511]=6; image[33512]=6; image[33513]=5; image[33514]=4; image[33515]=2; image[33516]=2; image[33517]=5; image[33518]=10; image[33519]=12; image[33520]=12; image[33521]=13; image[33522]=14; image[33523]=15; image[33524]=16; image[33525]=18; image[33526]=20; image[33527]=20; image[33528]=19; image[33529]=22; image[33530]=22; image[33531]=20; image[33532]=21; image[33533]=22; image[33534]=25; image[33535]=23; image[33536]=22; image[33537]=26; image[33538]=27; image[33539]=21; image[33540]=15; image[33541]=14; image[33542]=22; image[33543]=25; image[33544]=26; image[33545]=27; image[33546]=38; image[33547]=36; image[33548]=39; image[33549]=35; image[33550]=48; image[33551]=44; image[33552]=31; image[33553]=11; image[33554]=12; image[33555]=37; image[33556]=24; image[33557]=5; image[33558]=25; image[33559]=47; image[33560]=41; image[33561]=40; image[33562]=48; image[33563]=53; image[33564]=52; image[33565]=45; image[33566]=73; image[33567]=105; image[33568]=69; image[33569]=51; image[33570]=58; image[33571]=62; image[33572]=82; image[33573]=79; image[33574]=92; image[33575]=93; image[33576]=93; image[33577]=98; image[33578]=104; image[33579]=111; image[33580]=131; image[33581]=154; image[33582]=242; image[33583]=225; image[33584]=171; image[33585]=73; image[33586]=12; image[33587]=12; image[33588]=2; image[33589]=1; image[33590]=1; image[33591]=1; image[33592]=1; image[33593]=1; image[33594]=1; image[33595]=1; image[33596]=1; image[33597]=1; image[33598]=1; image[33599]=1; image[33600]=1; image[33601]=1; image[33602]=0; image[33603]=1; image[33604]=1; image[33605]=1; image[33606]=1; image[33607]=1; image[33608]=1; image[33609]=1; image[33610]=1; image[33611]=1; image[33612]=1; image[33613]=1; image[33614]=1; image[33615]=1; image[33616]=1; image[33617]=1; image[33618]=1; image[33619]=1; image[33620]=1; image[33621]=1; image[33622]=1; image[33623]=1; image[33624]=1; image[33625]=1; image[33626]=1; image[33627]=1; image[33628]=1; image[33629]=1; image[33630]=1; image[33631]=1; image[33632]=1; image[33633]=1; image[33634]=1; image[33635]=1; image[33636]=1; image[33637]=1; image[33638]=1; image[33639]=1; image[33640]=1; image[33641]=1; image[33642]=1; image[33643]=1; image[33644]=1; image[33645]=1; image[33646]=1; image[33647]=1; image[33648]=1; image[33649]=1; image[33650]=1; image[33651]=1; image[33652]=1; image[33653]=1; image[33654]=1; image[33655]=1; image[33656]=1; image[33657]=1; image[33658]=1; image[33659]=1; image[33660]=1; image[33661]=1; image[33662]=1; image[33663]=1; image[33664]=1; image[33665]=1; image[33666]=1; image[33667]=1; image[33668]=1; image[33669]=1; image[33670]=1; image[33671]=1; image[33672]=1; image[33673]=1; image[33674]=1; image[33675]=1; image[33676]=1; image[33677]=1; image[33678]=1; image[33679]=1; image[33680]=1; image[33681]=1; image[33682]=1; image[33683]=1; image[33684]=1; image[33685]=1; image[33686]=1; image[33687]=1; image[33688]=1; image[33689]=1; image[33690]=1; image[33691]=1; image[33692]=1; image[33693]=2; image[33694]=3; image[33695]=3; image[33696]=2; image[33697]=1; image[33698]=1; image[33699]=1; image[33700]=1; image[33701]=1; image[33702]=1; image[33703]=1; image[33704]=1; image[33705]=1; image[33706]=1; image[33707]=2; image[33708]=3; image[33709]=5; image[33710]=7; image[33711]=6; image[33712]=4; image[33713]=4; image[33714]=3; image[33715]=4; image[33716]=6; image[33717]=9; image[33718]=10; image[33719]=10; image[33720]=12; image[33721]=13; image[33722]=14; image[33723]=16; image[33724]=18; image[33725]=20; image[33726]=22; image[33727]=22; image[33728]=20; image[33729]=22; image[33730]=23; image[33731]=21; image[33732]=24; image[33733]=24; image[33734]=26; image[33735]=27; image[33736]=29; image[33737]=29; image[33738]=24; image[33739]=21; image[33740]=14; image[33741]=22; image[33742]=25; image[33743]=24; image[33744]=27; image[33745]=34; image[33746]=34; image[33747]=39; image[33748]=38; image[33749]=45; image[33750]=43; image[33751]=34; image[33752]=13; image[33753]=9; image[33754]=40; image[33755]=49; image[33756]=15; image[33757]=24; image[33758]=44; image[33759]=42; image[33760]=44; image[33761]=45; image[33762]=54; image[33763]=46; image[33764]=49; image[33765]=65; image[33766]=80; image[33767]=67; image[33768]=42; image[33769]=84; image[33770]=76; image[33771]=75; image[33772]=78; image[33773]=94; image[33774]=98; image[33775]=91; image[33776]=99; image[33777]=113; image[33778]=112; image[33779]=128; image[33780]=146; image[33781]=231; image[33782]=219; image[33783]=163; image[33784]=77; image[33785]=12; image[33786]=16; image[33787]=3; image[33788]=1; image[33789]=1; image[33790]=1; image[33791]=1; image[33792]=1; image[33793]=1; image[33794]=1; image[33795]=1; image[33796]=1; image[33797]=1; image[33798]=1; image[33799]=1; image[33800]=1; image[33801]=1; image[33802]=1; image[33803]=1; image[33804]=1; image[33805]=1; image[33806]=1; image[33807]=1; image[33808]=1; image[33809]=1; image[33810]=1; image[33811]=1; image[33812]=1; image[33813]=1; image[33814]=1; image[33815]=1; image[33816]=1; image[33817]=1; image[33818]=1; image[33819]=1; image[33820]=1; image[33821]=1; image[33822]=1; image[33823]=1; image[33824]=1; image[33825]=1; image[33826]=1; image[33827]=1; image[33828]=1; image[33829]=1; image[33830]=1; image[33831]=1; image[33832]=1; image[33833]=1; image[33834]=1; image[33835]=1; image[33836]=1; image[33837]=1; image[33838]=1; image[33839]=1; image[33840]=1; image[33841]=1; image[33842]=1; image[33843]=1; image[33844]=1; image[33845]=1; image[33846]=1; image[33847]=1; image[33848]=1; image[33849]=1; image[33850]=1; image[33851]=1; image[33852]=1; image[33853]=1; image[33854]=1; image[33855]=1; image[33856]=1; image[33857]=1; image[33858]=1; image[33859]=1; image[33860]=1; image[33861]=1; image[33862]=1; image[33863]=1; image[33864]=1; image[33865]=1; image[33866]=1; image[33867]=1; image[33868]=1; image[33869]=1; image[33870]=1; image[33871]=1; image[33872]=1; image[33873]=1; image[33874]=1; image[33875]=1; image[33876]=1; image[33877]=1; image[33878]=1; image[33879]=1; image[33880]=1; image[33881]=1; image[33882]=1; image[33883]=1; image[33884]=1; image[33885]=1; image[33886]=1; image[33887]=1; image[33888]=1; image[33889]=1; image[33890]=1; image[33891]=1; image[33892]=2; image[33893]=2; image[33894]=3; image[33895]=2; image[33896]=1; image[33897]=1; image[33898]=0; image[33899]=1; image[33900]=1; image[33901]=1; image[33902]=1; image[33903]=1; image[33904]=1; image[33905]=1; image[33906]=3; image[33907]=4; image[33908]=5; image[33909]=6; image[33910]=7; image[33911]=5; image[33912]=4; image[33913]=3; image[33914]=5; image[33915]=7; image[33916]=8; image[33917]=8; image[33918]=10; image[33919]=11; image[33920]=12; image[33921]=12; image[33922]=13; image[33923]=15; image[33924]=17; image[33925]=18; image[33926]=21; image[33927]=19; image[33928]=22; image[33929]=24; image[33930]=22; image[33931]=24; image[33932]=21; image[33933]=27; image[33934]=26; image[33935]=26; image[33936]=32; image[33937]=34; image[33938]=25; image[33939]=14; image[33940]=23; image[33941]=25; image[33942]=25; image[33943]=31; image[33944]=34; image[33945]=33; image[33946]=40; image[33947]=40; image[33948]=38; image[33949]=40; image[33950]=42; image[33951]=23; image[33952]=7; image[33953]=33; image[33954]=43; image[33955]=18; image[33956]=32; image[33957]=53; image[33958]=46; image[33959]=46; image[33960]=48; image[33961]=56; image[33962]=47; image[33963]=65; image[33964]=66; image[33965]=57; image[33966]=63; image[33967]=54; image[33968]=89; image[33969]=81; image[33970]=77; image[33971]=80; image[33972]=89; image[33973]=105; image[33974]=96; image[33975]=94; image[33976]=104; image[33977]=115; image[33978]=132; image[33979]=145; image[33980]=228; image[33981]=230; image[33982]=194; image[33983]=85; image[33984]=10; image[33985]=16; image[33986]=3; image[33987]=1; image[33988]=1; image[33989]=1; image[33990]=1; image[33991]=1; image[33992]=1; image[33993]=1; image[33994]=1; image[33995]=1; image[33996]=1; image[33997]=1; image[33998]=1; image[33999]=1; image[34000]=1; image[34001]=1; image[34002]=1; image[34003]=1; image[34004]=1; image[34005]=1; image[34006]=1; image[34007]=1; image[34008]=1; image[34009]=1; image[34010]=1; image[34011]=1; image[34012]=1; image[34013]=1; image[34014]=1; image[34015]=1; image[34016]=1; image[34017]=1; image[34018]=1; image[34019]=1; image[34020]=1; image[34021]=1; image[34022]=1; image[34023]=1; image[34024]=1; image[34025]=1; image[34026]=1; image[34027]=1; image[34028]=1; image[34029]=1; image[34030]=1; image[34031]=1; image[34032]=1; image[34033]=1; image[34034]=1; image[34035]=1; image[34036]=1; image[34037]=1; image[34038]=1; image[34039]=1; image[34040]=1; image[34041]=1; image[34042]=1; image[34043]=1; image[34044]=1; image[34045]=1; image[34046]=1; image[34047]=1; image[34048]=1; image[34049]=1; image[34050]=1; image[34051]=1; image[34052]=1; image[34053]=1; image[34054]=1; image[34055]=1; image[34056]=1; image[34057]=1; image[34058]=1; image[34059]=1; image[34060]=1; image[34061]=1; image[34062]=1; image[34063]=1; image[34064]=1; image[34065]=1; image[34066]=1; image[34067]=1; image[34068]=1; image[34069]=1; image[34070]=1; image[34071]=1; image[34072]=1; image[34073]=1; image[34074]=1; image[34075]=1; image[34076]=1; image[34077]=1; image[34078]=1; image[34079]=1; image[34080]=1; image[34081]=1; image[34082]=1; image[34083]=1; image[34084]=1; image[34085]=1; image[34086]=1; image[34087]=1; image[34088]=1; image[34089]=1; image[34090]=1; image[34091]=2; image[34092]=3; image[34093]=3; image[34094]=2; image[34095]=1; image[34096]=1; image[34097]=1; image[34098]=1; image[34099]=1; image[34100]=1; image[34101]=1; image[34102]=1; image[34103]=1; image[34104]=1; image[34105]=3; image[34106]=4; image[34107]=6; image[34108]=6; image[34109]=6; image[34110]=4; image[34111]=4; image[34112]=2; image[34113]=6; image[34114]=8; image[34115]=8; image[34116]=9; image[34117]=9; image[34118]=9; image[34119]=10; image[34120]=10; image[34121]=10; image[34122]=11; image[34123]=15; image[34124]=15; image[34125]=16; image[34126]=16; image[34127]=17; image[34128]=19; image[34129]=19; image[34130]=22; image[34131]=20; image[34132]=23; image[34133]=26; image[34134]=26; image[34135]=28; image[34136]=28; image[34137]=18; image[34138]=18; image[34139]=24; image[34140]=23; image[34141]=23; image[34142]=32; image[34143]=31; image[34144]=33; image[34145]=36; image[34146]=41; image[34147]=44; image[34148]=47; image[34149]=52; image[34150]=28; image[34151]=4; image[34152]=40; image[34153]=52; image[34154]=28; image[34155]=42; image[34156]=60; image[34157]=53; image[34158]=47; image[34159]=55; image[34160]=56; image[34161]=52; image[34162]=66; image[34163]=56; image[34164]=54; image[34165]=49; image[34166]=59; image[34167]=76; image[34168]=91; image[34169]=87; image[34170]=75; image[34171]=91; image[34172]=108; image[34173]=100; image[34174]=102; image[34175]=110; image[34176]=132; image[34177]=136; image[34178]=149; image[34179]=220; image[34180]=246; image[34181]=180; image[34182]=57; image[34183]=13; image[34184]=15; image[34185]=3; image[34186]=1; image[34187]=1; image[34188]=1; image[34189]=1; image[34190]=1; image[34191]=0; image[34192]=1; image[34193]=1; image[34194]=1; image[34195]=1; image[34196]=1; image[34197]=1; image[34198]=1; image[34199]=1; image[34200]=1; image[34201]=1; image[34202]=1; image[34203]=1; image[34204]=1; image[34205]=1; image[34206]=1; image[34207]=1; image[34208]=1; image[34209]=1; image[34210]=1; image[34211]=1; image[34212]=1; image[34213]=1; image[34214]=1; image[34215]=1; image[34216]=1; image[34217]=1; image[34218]=1; image[34219]=1; image[34220]=1; image[34221]=1; image[34222]=1; image[34223]=1; image[34224]=1; image[34225]=1; image[34226]=1; image[34227]=1; image[34228]=1; image[34229]=1; image[34230]=1; image[34231]=1; image[34232]=1; image[34233]=1; image[34234]=1; image[34235]=1; image[34236]=1; image[34237]=1; image[34238]=1; image[34239]=1; image[34240]=1; image[34241]=1; image[34242]=1; image[34243]=1; image[34244]=1; image[34245]=1; image[34246]=1; image[34247]=1; image[34248]=1; image[34249]=1; image[34250]=1; image[34251]=1; image[34252]=1; image[34253]=1; image[34254]=1; image[34255]=1; image[34256]=1; image[34257]=1; image[34258]=1; image[34259]=1; image[34260]=1; image[34261]=1; image[34262]=1; image[34263]=1; image[34264]=1; image[34265]=1; image[34266]=1; image[34267]=1; image[34268]=1; image[34269]=1; image[34270]=1; image[34271]=1; image[34272]=1; image[34273]=1; image[34274]=1; image[34275]=1; image[34276]=1; image[34277]=1; image[34278]=1; image[34279]=1; image[34280]=1; image[34281]=1; image[34282]=1; image[34283]=1; image[34284]=1; image[34285]=1; image[34286]=1; image[34287]=1; image[34288]=1; image[34289]=1; image[34290]=2; image[34291]=2; image[34292]=2; image[34293]=1; image[34294]=1; image[34295]=1; image[34296]=1; image[34297]=1; image[34298]=1; image[34299]=1; image[34300]=1; image[34301]=1; image[34302]=1; image[34303]=1; image[34304]=3; image[34305]=5; image[34306]=6; image[34307]=6; image[34308]=5; image[34309]=4; image[34310]=4; image[34311]=2; image[34312]=3; image[34313]=4; image[34314]=6; image[34315]=7; image[34316]=7; image[34317]=8; image[34318]=9; image[34319]=10; image[34320]=10; image[34321]=9; image[34322]=11; image[34323]=12; image[34324]=13; image[34325]=13; image[34326]=14; image[34327]=17; image[34328]=17; image[34329]=18; image[34330]=21; image[34331]=22; image[34332]=25; image[34333]=26; image[34334]=26; image[34335]=26; image[34336]=14; image[34337]=20; image[34338]=26; image[34339]=24; image[34340]=23; image[34341]=32; image[34342]=28; image[34343]=35; image[34344]=37; image[34345]=40; image[34346]=47; image[34347]=46; image[34348]=51; image[34349]=23; image[34350]=2; image[34351]=31; image[34352]=51; image[34353]=33; image[34354]=45; image[34355]=79; image[34356]=86; image[34357]=59; image[34358]=45; image[34359]=52; image[34360]=63; image[34361]=58; image[34362]=51; image[34363]=53; image[34364]=43; image[34365]=54; image[34366]=61; image[34367]=82; image[34368]=106; image[34369]=83; image[34370]=98; image[34371]=105; image[34372]=104; image[34373]=112; image[34374]=126; image[34375]=144; image[34376]=136; image[34377]=175; image[34378]=242; image[34379]=231; image[34380]=150; image[34381]=42; image[34382]=16; image[34383]=14; image[34384]=3; image[34385]=1; image[34386]=1; image[34387]=1; image[34388]=1; image[34389]=1; image[34390]=1; image[34391]=1; image[34392]=1; image[34393]=1; image[34394]=1; image[34395]=1; image[34396]=1; image[34397]=1; image[34398]=1; image[34399]=1; image[34400]=1; image[34401]=1; image[34402]=1; image[34403]=1; image[34404]=1; image[34405]=1; image[34406]=1; image[34407]=1; image[34408]=1; image[34409]=1; image[34410]=1; image[34411]=1; image[34412]=1; image[34413]=1; image[34414]=0; image[34415]=1; image[34416]=1; image[34417]=1; image[34418]=1; image[34419]=1; image[34420]=1; image[34421]=1; image[34422]=1; image[34423]=1; image[34424]=1; image[34425]=1; image[34426]=1; image[34427]=1; image[34428]=1; image[34429]=1; image[34430]=1; image[34431]=1; image[34432]=1; image[34433]=1; image[34434]=1; image[34435]=1; image[34436]=1; image[34437]=1; image[34438]=1; image[34439]=1; image[34440]=1; image[34441]=1; image[34442]=1; image[34443]=1; image[34444]=1; image[34445]=1; image[34446]=1; image[34447]=1; image[34448]=1; image[34449]=1; image[34450]=1; image[34451]=1; image[34452]=1; image[34453]=1; image[34454]=1; image[34455]=1; image[34456]=1; image[34457]=1; image[34458]=1; image[34459]=1; image[34460]=1; image[34461]=1; image[34462]=1; image[34463]=1; image[34464]=1; image[34465]=1; image[34466]=1; image[34467]=1; image[34468]=1; image[34469]=1; image[34470]=1; image[34471]=1; image[34472]=1; image[34473]=1; image[34474]=1; image[34475]=1; image[34476]=1; image[34477]=1; image[34478]=1; image[34479]=1; image[34480]=1; image[34481]=1; image[34482]=1; image[34483]=1; image[34484]=1; image[34485]=1; image[34486]=1; image[34487]=1; image[34488]=1; image[34489]=1; image[34490]=2; image[34491]=2; image[34492]=1; image[34493]=1; image[34494]=1; image[34495]=1; image[34496]=1; image[34497]=1; image[34498]=1; image[34499]=1; image[34500]=1; image[34501]=1; image[34502]=2; image[34503]=4; image[34504]=5; image[34505]=6; image[34506]=5; image[34507]=5; image[34508]=6; image[34509]=4; image[34510]=2; image[34511]=2; image[34512]=2; image[34513]=2; image[34514]=2; image[34515]=3; image[34516]=4; image[34517]=5; image[34518]=6; image[34519]=6; image[34520]=5; image[34521]=6; image[34522]=7; image[34523]=8; image[34524]=9; image[34525]=9; image[34526]=12; image[34527]=13; image[34528]=13; image[34529]=12; image[34530]=13; image[34531]=19; image[34532]=23; image[34533]=22; image[34534]=18; image[34535]=11; image[34536]=18; image[34537]=26; image[34538]=22; image[34539]=19; image[34540]=30; image[34541]=29; image[34542]=33; image[34543]=38; image[34544]=42; image[34545]=46; image[34546]=38; image[34547]=44; image[34548]=18; image[34549]=1; image[34550]=23; image[34551]=48; image[34552]=33; image[34553]=51; image[34554]=102; image[34555]=101; image[34556]=80; image[34557]=49; image[34558]=57; image[34559]=63; image[34560]=50; image[34561]=58; image[34562]=54; image[34563]=43; image[34564]=55; image[34565]=55; image[34566]=67; image[34567]=123; image[34568]=85; image[34569]=83; image[34570]=99; image[34571]=105; image[34572]=117; image[34573]=129; image[34574]=143; image[34575]=163; image[34576]=182; image[34577]=255; image[34578]=222; image[34579]=163; image[34580]=59; image[34581]=20; image[34582]=16; image[34583]=3; image[34584]=1; image[34585]=1; image[34586]=1; image[34587]=1; image[34588]=1; image[34589]=1; image[34590]=1; image[34591]=1; image[34592]=1; image[34593]=1; image[34594]=1; image[34595]=1; image[34596]=1; image[34597]=1; image[34598]=1; image[34599]=1; image[34600]=1; image[34601]=1; image[34602]=1; image[34603]=1; image[34604]=1; image[34605]=1; image[34606]=1; image[34607]=1; image[34608]=1; image[34609]=1; image[34610]=1; image[34611]=1; image[34612]=1; image[34613]=1; image[34614]=1; image[34615]=1; image[34616]=1; image[34617]=1; image[34618]=1; image[34619]=1; image[34620]=1; image[34621]=1; image[34622]=1; image[34623]=1; image[34624]=1; image[34625]=1; image[34626]=1; image[34627]=1; image[34628]=1; image[34629]=1; image[34630]=1; image[34631]=1; image[34632]=1; image[34633]=1; image[34634]=1; image[34635]=1; image[34636]=1; image[34637]=1; image[34638]=1; image[34639]=1; image[34640]=1; image[34641]=1; image[34642]=1; image[34643]=1; image[34644]=1; image[34645]=1; image[34646]=1; image[34647]=1; image[34648]=1; image[34649]=1; image[34650]=1; image[34651]=1; image[34652]=1; image[34653]=1; image[34654]=1; image[34655]=1; image[34656]=1; image[34657]=1; image[34658]=1; image[34659]=1; image[34660]=1; image[34661]=1; image[34662]=1; image[34663]=1; image[34664]=1; image[34665]=1; image[34666]=1; image[34667]=1; image[34668]=1; image[34669]=1; image[34670]=1; image[34671]=1; image[34672]=1; image[34673]=1; image[34674]=1; image[34675]=1; image[34676]=1; image[34677]=1; image[34678]=1; image[34679]=1; image[34680]=1; image[34681]=1; image[34682]=1; image[34683]=1; image[34684]=1; image[34685]=1; image[34686]=1; image[34687]=1; image[34688]=1; image[34689]=1; image[34690]=2; image[34691]=1; image[34692]=1; image[34693]=1; image[34694]=1; image[34695]=1; image[34696]=1; image[34697]=1; image[34698]=1; image[34699]=1; image[34700]=1; image[34701]=2; image[34702]=5; image[34703]=5; image[34704]=6; image[34705]=5; image[34706]=5; image[34707]=7; image[34708]=6; image[34709]=3; image[34710]=3; image[34711]=4; image[34712]=3; image[34713]=4; image[34714]=5; image[34715]=5; image[34716]=5; image[34717]=4; image[34718]=5; image[34719]=6; image[34720]=8; image[34721]=9; image[34722]=9; image[34723]=10; image[34724]=9; image[34725]=7; image[34726]=7; image[34727]=9; image[34728]=12; image[34729]=11; image[34730]=11; image[34731]=14; image[34732]=17; image[34733]=16; image[34734]=7; image[34735]=15; image[34736]=30; image[34737]=24; image[34738]=21; image[34739]=30; image[34740]=27; image[34741]=35; image[34742]=36; image[34743]=42; image[34744]=46; image[34745]=37; image[34746]=40; image[34747]=12; image[34748]=1; image[34749]=11; image[34750]=35; image[34751]=39; image[34752]=56; image[34753]=95; image[34754]=91; image[34755]=59; image[34756]=48; image[34757]=66; image[34758]=58; image[34759]=51; image[34760]=54; image[34761]=50; image[34762]=44; image[34763]=51; image[34764]=53; image[34765]=63; image[34766]=108; image[34767]=119; image[34768]=88; image[34769]=97; image[34770]=104; image[34771]=115; image[34772]=122; image[34773]=127; image[34774]=147; image[34775]=140; image[34776]=232; image[34777]=245; image[34778]=189; image[34779]=62; image[34780]=22; image[34781]=13; image[34782]=2; image[34783]=1; image[34784]=1; image[34785]=1; image[34786]=1; image[34787]=1; image[34788]=1; image[34789]=1; image[34790]=1; image[34791]=1; image[34792]=1; image[34793]=1; image[34794]=1; image[34795]=1; image[34796]=1; image[34797]=1; image[34798]=1; image[34799]=1; image[34800]=1; image[34801]=1; image[34802]=1; image[34803]=1; image[34804]=1; image[34805]=1; image[34806]=1; image[34807]=1; image[34808]=1; image[34809]=1; image[34810]=1; image[34811]=1; image[34812]=1; image[34813]=1; image[34814]=1; image[34815]=1; image[34816]=1; image[34817]=1; image[34818]=1; image[34819]=1; image[34820]=1; image[34821]=1; image[34822]=1; image[34823]=1; image[34824]=1; image[34825]=1; image[34826]=1; image[34827]=1; image[34828]=1; image[34829]=1; image[34830]=1; image[34831]=1; image[34832]=1; image[34833]=1; image[34834]=1; image[34835]=1; image[34836]=1; image[34837]=1; image[34838]=1; image[34839]=1; image[34840]=1; image[34841]=1; image[34842]=1; image[34843]=1; image[34844]=1; image[34845]=1; image[34846]=1; image[34847]=1; image[34848]=1; image[34849]=1; image[34850]=1; image[34851]=1; image[34852]=1; image[34853]=1; image[34854]=1; image[34855]=1; image[34856]=1; image[34857]=1; image[34858]=1; image[34859]=1; image[34860]=1; image[34861]=1; image[34862]=1; image[34863]=1; image[34864]=1; image[34865]=1; image[34866]=1; image[34867]=1; image[34868]=1; image[34869]=1; image[34870]=1; image[34871]=1; image[34872]=1; image[34873]=1; image[34874]=1; image[34875]=1; image[34876]=1; image[34877]=1; image[34878]=1; image[34879]=1; image[34880]=1; image[34881]=1; image[34882]=1; image[34883]=1; image[34884]=1; image[34885]=1; image[34886]=1; image[34887]=1; image[34888]=1; image[34889]=1; image[34890]=1; image[34891]=1; image[34892]=1; image[34893]=1; image[34894]=1; image[34895]=1; image[34896]=1; image[34897]=1; image[34898]=1; image[34899]=1; image[34900]=3; image[34901]=4; image[34902]=5; image[34903]=5; image[34904]=5; image[34905]=4; image[34906]=6; image[34907]=5; image[34908]=4; image[34909]=6; image[34910]=7; image[34911]=8; image[34912]=12; image[34913]=14; image[34914]=17; image[34915]=16; image[34916]=15; image[34917]=17; image[34918]=19; image[34919]=23; image[34920]=25; image[34921]=26; image[34922]=24; image[34923]=25; image[34924]=22; image[34925]=17; image[34926]=14; image[34927]=10; image[34928]=7; image[34929]=9; image[34930]=11; image[34931]=15; image[34932]=15; image[34933]=6; image[34934]=16; image[34935]=27; image[34936]=22; image[34937]=24; image[34938]=33; image[34939]=24; image[34940]=37; image[34941]=40; image[34942]=44; image[34943]=44; image[34944]=40; image[34945]=32; image[34946]=6; image[34947]=0; image[34948]=6; image[34949]=32; image[34950]=42; image[34951]=48; image[34952]=86; image[34953]=88; image[34954]=64; image[34955]=74; image[34956]=64; image[34957]=51; image[34958]=49; image[34959]=52; image[34960]=50; image[34961]=52; image[34962]=52; image[34963]=51; image[34964]=64; image[34965]=78; image[34966]=117; image[34967]=93; image[34968]=103; image[34969]=104; image[34970]=117; image[34971]=128; image[34972]=124; image[34973]=135; image[34974]=144; image[34975]=222; image[34976]=251; image[34977]=225; image[34978]=60; image[34979]=18; image[34980]=13; image[34981]=2; image[34982]=1; image[34983]=1; image[34984]=1; image[34985]=1; image[34986]=1; image[34987]=1; image[34988]=1; image[34989]=1; image[34990]=1; image[34991]=1; image[34992]=1; image[34993]=1; image[34994]=1; image[34995]=1; image[34996]=1; image[34997]=1; image[34998]=1; image[34999]=1; image[35000]=1; image[35001]=1; image[35002]=1; image[35003]=1; image[35004]=1; image[35005]=1; image[35006]=1; image[35007]=1; image[35008]=1; image[35009]=1; image[35010]=1; image[35011]=1; image[35012]=1; image[35013]=1; image[35014]=1; image[35015]=1; image[35016]=1; image[35017]=1; image[35018]=1; image[35019]=1; image[35020]=1; image[35021]=1; image[35022]=1; image[35023]=1; image[35024]=1; image[35025]=1; image[35026]=1; image[35027]=1; image[35028]=1; image[35029]=1; image[35030]=1; image[35031]=1; image[35032]=1; image[35033]=1; image[35034]=1; image[35035]=1; image[35036]=1; image[35037]=1; image[35038]=1; image[35039]=1; image[35040]=1; image[35041]=1; image[35042]=1; image[35043]=1; image[35044]=1; image[35045]=1; image[35046]=1; image[35047]=1; image[35048]=1; image[35049]=1; image[35050]=1; image[35051]=1; image[35052]=1; image[35053]=1; image[35054]=1; image[35055]=1; image[35056]=1; image[35057]=1; image[35058]=1; image[35059]=1; image[35060]=1; image[35061]=1; image[35062]=1; image[35063]=1; image[35064]=1; image[35065]=1; image[35066]=1; image[35067]=1; image[35068]=1; image[35069]=1; image[35070]=1; image[35071]=1; image[35072]=1; image[35073]=1; image[35074]=1; image[35075]=1; image[35076]=1; image[35077]=1; image[35078]=1; image[35079]=1; image[35080]=1; image[35081]=1; image[35082]=1; image[35083]=1; image[35084]=1; image[35085]=1; image[35086]=1; image[35087]=1; image[35088]=1; image[35089]=1; image[35090]=1; image[35091]=1; image[35092]=1; image[35093]=1; image[35094]=1; image[35095]=1; image[35096]=1; image[35097]=1; image[35098]=2; image[35099]=3; image[35100]=4; image[35101]=4; image[35102]=5; image[35103]=5; image[35104]=5; image[35105]=6; image[35106]=4; image[35107]=2; image[35108]=4; image[35109]=6; image[35110]=10; image[35111]=13; image[35112]=16; image[35113]=22; image[35114]=20; image[35115]=20; image[35116]=22; image[35117]=23; image[35118]=24; image[35119]=25; image[35120]=27; image[35121]=26; image[35122]=26; image[35123]=27; image[35124]=31; image[35125]=37; image[35126]=29; image[35127]=13; image[35128]=6; image[35129]=4; image[35130]=4; image[35131]=7; image[35132]=5; image[35133]=21; image[35134]=29; image[35135]=22; image[35136]=23; image[35137]=31; image[35138]=28; image[35139]=38; image[35140]=39; image[35141]=46; image[35142]=43; image[35143]=41; image[35144]=31; image[35145]=5; image[35146]=1; image[35147]=2; image[35148]=25; image[35149]=33; image[35150]=47; image[35151]=68; image[35152]=73; image[35153]=128; image[35154]=84; image[35155]=49; image[35156]=52; image[35157]=52; image[35158]=56; image[35159]=51; image[35160]=62; image[35161]=57; image[35162]=62; image[35163]=72; image[35164]=74; image[35165]=104; image[35166]=104; image[35167]=100; image[35168]=113; image[35169]=124; image[35170]=121; image[35171]=115; image[35172]=134; image[35173]=154; image[35174]=232; image[35175]=255; image[35176]=213; image[35177]=48; image[35178]=21; image[35179]=13; image[35180]=2; image[35181]=1; image[35182]=1; image[35183]=1; image[35184]=1; image[35185]=1; image[35186]=1; image[35187]=1; image[35188]=1; image[35189]=1; image[35190]=1; image[35191]=1; image[35192]=1; image[35193]=1; image[35194]=1; image[35195]=1; image[35196]=1; image[35197]=1; image[35198]=1; image[35199]=1; image[35200]=1; image[35201]=1; image[35202]=1; image[35203]=1; image[35204]=1; image[35205]=1; image[35206]=1; image[35207]=1; image[35208]=1; image[35209]=1; image[35210]=1; image[35211]=1; image[35212]=1; image[35213]=1; image[35214]=1; image[35215]=1; image[35216]=1; image[35217]=1; image[35218]=1; image[35219]=1; image[35220]=1; image[35221]=1; image[35222]=1; image[35223]=1; image[35224]=1; image[35225]=1; image[35226]=1; image[35227]=1; image[35228]=1; image[35229]=1; image[35230]=1; image[35231]=1; image[35232]=1; image[35233]=1; image[35234]=1; image[35235]=1; image[35236]=1; image[35237]=1; image[35238]=1; image[35239]=1; image[35240]=1; image[35241]=1; image[35242]=1; image[35243]=1; image[35244]=1; image[35245]=1; image[35246]=1; image[35247]=1; image[35248]=1; image[35249]=1; image[35250]=1; image[35251]=1; image[35252]=1; image[35253]=1; image[35254]=1; image[35255]=1; image[35256]=1; image[35257]=1; image[35258]=1; image[35259]=1; image[35260]=1; image[35261]=1; image[35262]=1; image[35263]=1; image[35264]=1; image[35265]=1; image[35266]=1; image[35267]=1; image[35268]=1; image[35269]=1; image[35270]=1; image[35271]=1; image[35272]=1; image[35273]=1; image[35274]=1; image[35275]=1; image[35276]=1; image[35277]=1; image[35278]=1; image[35279]=1; image[35280]=1; image[35281]=1; image[35282]=1; image[35283]=1; image[35284]=1; image[35285]=1; image[35286]=1; image[35287]=1; image[35288]=1; image[35289]=1; image[35290]=1; image[35291]=1; image[35292]=1; image[35293]=1; image[35294]=1; image[35295]=1; image[35296]=1; image[35297]=2; image[35298]=4; image[35299]=5; image[35300]=5; image[35301]=6; image[35302]=5; image[35303]=5; image[35304]=6; image[35305]=3; image[35306]=2; image[35307]=2; image[35308]=3; image[35309]=3; image[35310]=5; image[35311]=8; image[35312]=14; image[35313]=16; image[35314]=22; image[35315]=25; image[35316]=26; image[35317]=25; image[35318]=29; image[35319]=30; image[35320]=25; image[35321]=26; image[35322]=27; image[35323]=28; image[35324]=31; image[35325]=31; image[35326]=26; image[35327]=22; image[35328]=18; image[35329]=11; image[35330]=5; image[35331]=6; image[35332]=28; image[35333]=29; image[35334]=23; image[35335]=27; image[35336]=34; image[35337]=29; image[35338]=41; image[35339]=39; image[35340]=45; image[35341]=49; image[35342]=47; image[35343]=36; image[35344]=5; image[35345]=1; image[35346]=1; image[35347]=21; image[35348]=27; image[35349]=34; image[35350]=53; image[35351]=164; image[35352]=123; image[35353]=40; image[35354]=43; image[35355]=54; image[35356]=55; image[35357]=59; image[35358]=55; image[35359]=65; image[35360]=55; image[35361]=65; image[35362]=69; image[35363]=74; image[35364]=110; image[35365]=110; image[35366]=96; image[35367]=117; image[35368]=127; image[35369]=135; image[35370]=121; image[35371]=144; image[35372]=164; image[35373]=236; image[35374]=218; image[35375]=137; image[35376]=34; image[35377]=22; image[35378]=11; image[35379]=1; image[35380]=1; image[35381]=1; image[35382]=1; image[35383]=1; image[35384]=1; image[35385]=1; image[35386]=1; image[35387]=1; image[35388]=1; image[35389]=1; image[35390]=1; image[35391]=1; image[35392]=1; image[35393]=1; image[35394]=1; image[35395]=1; image[35396]=1; image[35397]=1; image[35398]=1; image[35399]=1; image[35400]=1; image[35401]=1; image[35402]=1; image[35403]=1; image[35404]=1; image[35405]=1; image[35406]=1; image[35407]=1; image[35408]=1; image[35409]=1; image[35410]=1; image[35411]=1; image[35412]=1; image[35413]=1; image[35414]=1; image[35415]=1; image[35416]=1; image[35417]=1; image[35418]=1; image[35419]=1; image[35420]=1; image[35421]=1; image[35422]=1; image[35423]=1; image[35424]=1; image[35425]=1; image[35426]=1; image[35427]=1; image[35428]=1; image[35429]=1; image[35430]=1; image[35431]=1; image[35432]=1; image[35433]=1; image[35434]=1; image[35435]=1; image[35436]=1; image[35437]=1; image[35438]=1; image[35439]=1; image[35440]=1; image[35441]=1; image[35442]=1; image[35443]=1; image[35444]=1; image[35445]=1; image[35446]=1; image[35447]=1; image[35448]=1; image[35449]=1; image[35450]=1; image[35451]=1; image[35452]=1; image[35453]=1; image[35454]=1; image[35455]=1; image[35456]=1; image[35457]=1; image[35458]=1; image[35459]=1; image[35460]=1; image[35461]=1; image[35462]=1; image[35463]=1; image[35464]=1; image[35465]=1; image[35466]=1; image[35467]=1; image[35468]=1; image[35469]=1; image[35470]=1; image[35471]=0; image[35472]=1; image[35473]=1; image[35474]=1; image[35475]=1; image[35476]=1; image[35477]=1; image[35478]=1; image[35479]=1; image[35480]=1; image[35481]=1; image[35482]=1; image[35483]=1; image[35484]=1; image[35485]=1; image[35486]=1; image[35487]=1; image[35488]=1; image[35489]=1; image[35490]=1; image[35491]=1; image[35492]=1; image[35493]=1; image[35494]=1; image[35495]=1; image[35496]=3; image[35497]=4; image[35498]=5; image[35499]=6; image[35500]=6; image[35501]=5; image[35502]=5; image[35503]=6; image[35504]=4; image[35505]=2; image[35506]=3; image[35507]=3; image[35508]=2; image[35509]=2; image[35510]=2; image[35511]=4; image[35512]=5; image[35513]=9; image[35514]=13; image[35515]=19; image[35516]=30; image[35517]=31; image[35518]=32; image[35519]=24; image[35520]=24; image[35521]=28; image[35522]=29; image[35523]=29; image[35524]=29; image[35525]=21; image[35526]=17; image[35527]=19; image[35528]=13; image[35529]=5; image[35530]=8; image[35531]=33; image[35532]=31; image[35533]=23; image[35534]=29; image[35535]=37; image[35536]=32; image[35537]=40; image[35538]=40; image[35539]=41; image[35540]=43; image[35541]=39; image[35542]=26; image[35543]=5; image[35544]=2; image[35545]=3; image[35546]=13; image[35547]=45; image[35548]=44; image[35549]=94; image[35550]=190; image[35551]=46; image[35552]=34; image[35553]=46; image[35554]=51; image[35555]=56; image[35556]=60; image[35557]=60; image[35558]=67; image[35559]=57; image[35560]=62; image[35561]=69; image[35562]=81; image[35563]=104; image[35564]=115; image[35565]=114; image[35566]=124; image[35567]=127; image[35568]=142; image[35569]=134; image[35570]=148; image[35571]=157; image[35572]=238; image[35573]=174; image[35574]=90; image[35575]=24; image[35576]=23; image[35577]=6; image[35578]=1; image[35579]=1; image[35580]=1; image[35581]=1; image[35582]=1; image[35583]=1; image[35584]=1; image[35585]=1; image[35586]=1; image[35587]=1; image[35588]=1; image[35589]=1; image[35590]=1; image[35591]=1; image[35592]=1; image[35593]=1; image[35594]=1; image[35595]=1; image[35596]=1; image[35597]=1; image[35598]=1; image[35599]=1; image[35600]=1; image[35601]=1; image[35602]=1; image[35603]=1; image[35604]=1; image[35605]=1; image[35606]=1; image[35607]=1; image[35608]=1; image[35609]=1; image[35610]=1; image[35611]=1; image[35612]=1; image[35613]=1; image[35614]=1; image[35615]=1; image[35616]=1; image[35617]=1; image[35618]=1; image[35619]=1; image[35620]=1; image[35621]=1; image[35622]=1; image[35623]=1; image[35624]=1; image[35625]=1; image[35626]=1; image[35627]=1; image[35628]=1; image[35629]=1; image[35630]=1; image[35631]=1; image[35632]=1; image[35633]=1; image[35634]=1; image[35635]=1; image[35636]=1; image[35637]=1; image[35638]=1; image[35639]=1; image[35640]=1; image[35641]=1; image[35642]=1; image[35643]=1; image[35644]=1; image[35645]=1; image[35646]=1; image[35647]=1; image[35648]=1; image[35649]=1; image[35650]=1; image[35651]=1; image[35652]=1; image[35653]=1; image[35654]=1; image[35655]=1; image[35656]=1; image[35657]=1; image[35658]=1; image[35659]=1; image[35660]=1; image[35661]=1; image[35662]=1; image[35663]=1; image[35664]=1; image[35665]=1; image[35666]=1; image[35667]=1; image[35668]=1; image[35669]=1; image[35670]=1; image[35671]=1; image[35672]=1; image[35673]=1; image[35674]=1; image[35675]=1; image[35676]=1; image[35677]=1; image[35678]=1; image[35679]=1; image[35680]=1; image[35681]=1; image[35682]=1; image[35683]=1; image[35684]=1; image[35685]=1; image[35686]=1; image[35687]=1; image[35688]=1; image[35689]=1; image[35690]=1; image[35691]=1; image[35692]=1; image[35693]=1; image[35694]=1; image[35695]=2; image[35696]=4; image[35697]=5; image[35698]=6; image[35699]=7; image[35700]=6; image[35701]=6; image[35702]=6; image[35703]=4; image[35704]=4; image[35705]=6; image[35706]=6; image[35707]=8; image[35708]=9; image[35709]=9; image[35710]=7; image[35711]=7; image[35712]=7; image[35713]=7; image[35714]=6; image[35715]=8; image[35716]=11; image[35717]=14; image[35718]=23; image[35719]=25; image[35720]=26; image[35721]=29; image[35722]=36; image[35723]=34; image[35724]=19; image[35725]=11; image[35726]=11; image[35727]=7; image[35728]=3; image[35729]=7; image[35730]=34; image[35731]=30; image[35732]=22; image[35733]=34; image[35734]=36; image[35735]=32; image[35736]=41; image[35737]=44; image[35738]=47; image[35739]=45; image[35740]=35; image[35741]=24; image[35742]=7; image[35743]=6; image[35744]=13; image[35745]=15; image[35746]=32; image[35747]=57; image[35748]=164; image[35749]=116; image[35750]=32; image[35751]=49; image[35752]=45; image[35753]=50; image[35754]=57; image[35755]=64; image[35756]=64; image[35757]=65; image[35758]=68; image[35759]=69; image[35760]=74; image[35761]=91; image[35762]=100; image[35763]=130; image[35764]=124; image[35765]=124; image[35766]=137; image[35767]=149; image[35768]=140; image[35769]=158; image[35770]=183; image[35771]=250; image[35772]=252; image[35773]=152; image[35774]=26; image[35775]=25; image[35776]=4; image[35777]=1; image[35778]=1; image[35779]=1; image[35780]=1; image[35781]=1; image[35782]=1; image[35783]=1; image[35784]=1; image[35785]=1; image[35786]=1; image[35787]=1; image[35788]=1; image[35789]=1; image[35790]=1; image[35791]=1; image[35792]=1; image[35793]=1; image[35794]=1; image[35795]=1; image[35796]=1; image[35797]=1; image[35798]=1; image[35799]=1; image[35800]=1; image[35801]=1; image[35802]=1; image[35803]=1; image[35804]=1; image[35805]=1; image[35806]=1; image[35807]=1; image[35808]=1; image[35809]=1; image[35810]=1; image[35811]=1; image[35812]=1; image[35813]=1; image[35814]=1; image[35815]=1; image[35816]=1; image[35817]=1; image[35818]=1; image[35819]=1; image[35820]=1; image[35821]=1; image[35822]=1; image[35823]=1; image[35824]=1; image[35825]=1; image[35826]=1; image[35827]=1; image[35828]=1; image[35829]=1; image[35830]=1; image[35831]=1; image[35832]=1; image[35833]=1; image[35834]=1; image[35835]=1; image[35836]=1; image[35837]=1; image[35838]=1; image[35839]=1; image[35840]=1; image[35841]=1; image[35842]=1; image[35843]=1; image[35844]=1; image[35845]=1; image[35846]=1; image[35847]=1; image[35848]=1; image[35849]=1; image[35850]=1; image[35851]=1; image[35852]=1; image[35853]=1; image[35854]=1; image[35855]=1; image[35856]=1; image[35857]=1; image[35858]=1; image[35859]=1; image[35860]=1; image[35861]=1; image[35862]=1; image[35863]=1; image[35864]=1; image[35865]=1; image[35866]=1; image[35867]=1; image[35868]=1; image[35869]=1; image[35870]=1; image[35871]=1; image[35872]=1; image[35873]=1; image[35874]=1; image[35875]=1; image[35876]=1; image[35877]=1; image[35878]=1; image[35879]=1; image[35880]=1; image[35881]=1; image[35882]=1; image[35883]=1; image[35884]=1; image[35885]=1; image[35886]=1; image[35887]=1; image[35888]=1; image[35889]=1; image[35890]=1; image[35891]=1; image[35892]=1; image[35893]=2; image[35894]=3; image[35895]=5; image[35896]=6; image[35897]=6; image[35898]=6; image[35899]=7; image[35900]=6; image[35901]=7; image[35902]=5; image[35903]=9; image[35904]=10; image[35905]=11; image[35906]=16; image[35907]=18; image[35908]=17; image[35909]=16; image[35910]=17; image[35911]=18; image[35912]=20; image[35913]=21; image[35914]=15; image[35915]=14; image[35916]=11; image[35917]=9; image[35918]=8; image[35919]=7; image[35920]=8; image[35921]=10; image[35922]=9; image[35923]=5; image[35924]=4; image[35925]=3; image[35926]=3; image[35927]=4; image[35928]=8; image[35929]=33; image[35930]=27; image[35931]=22; image[35932]=32; image[35933]=36; image[35934]=32; image[35935]=43; image[35936]=47; image[35937]=45; image[35938]=46; image[35939]=41; image[35940]=34; image[35941]=8; image[35942]=7; image[35943]=31; image[35944]=30; image[35945]=32; image[35946]=105; image[35947]=143; image[35948]=71; image[35949]=43; image[35950]=45; image[35951]=43; image[35952]=53; image[35953]=61; image[35954]=63; image[35955]=69; image[35956]=69; image[35957]=66; image[35958]=66; image[35959]=75; image[35960]=90; image[35961]=94; image[35962]=135; image[35963]=122; image[35964]=127; image[35965]=146; image[35966]=144; image[35967]=141; image[35968]=162; image[35969]=200; image[35970]=245; image[35971]=223; image[35972]=108; image[35973]=17; image[35974]=17; image[35975]=3; image[35976]=1; image[35977]=1; image[35978]=1; image[35979]=1; image[35980]=1; image[35981]=1; image[35982]=1; image[35983]=1; image[35984]=1; image[35985]=1; image[35986]=1; image[35987]=1; image[35988]=1; image[35989]=1; image[35990]=1; image[35991]=1; image[35992]=1; image[35993]=1; image[35994]=1; image[35995]=1; image[35996]=1; image[35997]=1; image[35998]=1; image[35999]=1; image[36000]=1; image[36001]=1; image[36002]=1; image[36003]=1; image[36004]=1; image[36005]=1; image[36006]=0; image[36007]=1; image[36008]=1; image[36009]=1; image[36010]=1; image[36011]=1; image[36012]=1; image[36013]=1; image[36014]=1; image[36015]=1; image[36016]=1; image[36017]=1; image[36018]=1; image[36019]=1; image[36020]=1; image[36021]=1; image[36022]=1; image[36023]=1; image[36024]=1; image[36025]=1; image[36026]=1; image[36027]=1; image[36028]=1; image[36029]=1; image[36030]=1; image[36031]=1; image[36032]=1; image[36033]=1; image[36034]=1; image[36035]=1; image[36036]=1; image[36037]=1; image[36038]=1; image[36039]=1; image[36040]=1; image[36041]=1; image[36042]=1; image[36043]=1; image[36044]=1; image[36045]=1; image[36046]=1; image[36047]=1; image[36048]=1; image[36049]=1; image[36050]=1; image[36051]=1; image[36052]=1; image[36053]=1; image[36054]=1; image[36055]=1; image[36056]=1; image[36057]=1; image[36058]=1; image[36059]=1; image[36060]=1; image[36061]=1; image[36062]=1; image[36063]=1; image[36064]=1; image[36065]=1; image[36066]=1; image[36067]=1; image[36068]=1; image[36069]=1; image[36070]=1; image[36071]=1; image[36072]=1; image[36073]=1; image[36074]=1; image[36075]=1; image[36076]=1; image[36077]=1; image[36078]=1; image[36079]=1; image[36080]=1; image[36081]=1; image[36082]=1; image[36083]=1; image[36084]=1; image[36085]=1; image[36086]=1; image[36087]=1; image[36088]=1; image[36089]=1; image[36090]=1; image[36091]=2; image[36092]=3; image[36093]=4; image[36094]=6; image[36095]=6; image[36096]=6; image[36097]=7; image[36098]=7; image[36099]=6; image[36100]=11; image[36101]=6; image[36102]=8; image[36103]=12; image[36104]=14; image[36105]=16; image[36106]=15; image[36107]=15; image[36108]=14; image[36109]=17; image[36110]=21; image[36111]=21; image[36112]=24; image[36113]=25; image[36114]=28; image[36115]=29; image[36116]=34; image[36117]=32; image[36118]=30; image[36119]=29; image[36120]=25; image[36121]=21; image[36122]=21; image[36123]=14; image[36124]=10; image[36125]=10; image[36126]=12; image[36127]=10; image[36128]=30; image[36129]=27; image[36130]=24; image[36131]=29; image[36132]=35; image[36133]=37; image[36134]=43; image[36135]=44; image[36136]=49; image[36137]=44; image[36138]=38; image[36139]=36; image[36140]=8; image[36141]=10; image[36142]=53; image[36143]=53; image[36144]=28; image[36145]=100; image[36146]=81; image[36147]=44; image[36148]=55; image[36149]=45; image[36150]=53; image[36151]=58; image[36152]=62; image[36153]=65; image[36154]=69; image[36155]=69; image[36156]=64; image[36157]=63; image[36158]=80; image[36159]=96; image[36160]=95; image[36161]=140; image[36162]=144; image[36163]=142; image[36164]=151; image[36165]=145; image[36166]=151; image[36167]=169; image[36168]=209; image[36169]=255; image[36170]=227; image[36171]=77; image[36172]=21; image[36173]=11; image[36174]=2; image[36175]=1; image[36176]=1; image[36177]=1; image[36178]=1; image[36179]=1; image[36180]=1; image[36181]=1; image[36182]=1; image[36183]=1; image[36184]=1; image[36185]=1; image[36186]=1; image[36187]=1; image[36188]=1; image[36189]=1; image[36190]=1; image[36191]=1; image[36192]=1; image[36193]=1; image[36194]=1; image[36195]=1; image[36196]=1; image[36197]=1; image[36198]=1; image[36199]=1; image[36200]=1; image[36201]=1; image[36202]=1; image[36203]=1; image[36204]=1; image[36205]=1; image[36206]=1; image[36207]=1; image[36208]=1; image[36209]=1; image[36210]=1; image[36211]=1; image[36212]=1; image[36213]=1; image[36214]=1; image[36215]=1; image[36216]=1; image[36217]=1; image[36218]=1; image[36219]=1; image[36220]=1; image[36221]=1; image[36222]=1; image[36223]=1; image[36224]=1; image[36225]=1; image[36226]=1; image[36227]=1; image[36228]=1; image[36229]=1; image[36230]=1; image[36231]=1; image[36232]=1; image[36233]=1; image[36234]=1; image[36235]=1; image[36236]=1; image[36237]=1; image[36238]=1; image[36239]=1; image[36240]=1; image[36241]=1; image[36242]=1; image[36243]=1; image[36244]=1; image[36245]=1; image[36246]=1; image[36247]=1; image[36248]=1; image[36249]=1; image[36250]=1; image[36251]=1; image[36252]=1; image[36253]=1; image[36254]=1; image[36255]=1; image[36256]=1; image[36257]=1; image[36258]=1; image[36259]=1; image[36260]=1; image[36261]=1; image[36262]=1; image[36263]=1; image[36264]=1; image[36265]=1; image[36266]=1; image[36267]=1; image[36268]=1; image[36269]=1; image[36270]=1; image[36271]=1; image[36272]=1; image[36273]=1; image[36274]=1; image[36275]=1; image[36276]=1; image[36277]=1; image[36278]=1; image[36279]=1; image[36280]=1; image[36281]=1; image[36282]=1; image[36283]=1; image[36284]=1; image[36285]=1; image[36286]=1; image[36287]=1; image[36288]=1; image[36289]=1; image[36290]=2; image[36291]=3; image[36292]=4; image[36293]=6; image[36294]=6; image[36295]=7; image[36296]=7; image[36297]=7; image[36298]=10; image[36299]=14; image[36300]=6; image[36301]=7; image[36302]=12; image[36303]=13; image[36304]=15; image[36305]=16; image[36306]=16; image[36307]=14; image[36308]=16; image[36309]=21; image[36310]=21; image[36311]=22; image[36312]=24; image[36313]=24; image[36314]=21; image[36315]=24; image[36316]=23; image[36317]=24; image[36318]=31; image[36319]=32; image[36320]=36; image[36321]=40; image[36322]=39; image[36323]=31; image[36324]=17; image[36325]=9; image[36326]=11; image[36327]=33; image[36328]=28; image[36329]=24; image[36330]=35; image[36331]=38; image[36332]=39; image[36333]=42; image[36334]=44; image[36335]=56; image[36336]=47; image[36337]=46; image[36338]=34; image[36339]=8; image[36340]=13; image[36341]=86; image[36342]=88; image[36343]=28; image[36344]=73; image[36345]=110; image[36346]=53; image[36347]=56; image[36348]=51; image[36349]=60; image[36350]=60; image[36351]=62; image[36352]=74; image[36353]=77; image[36354]=74; image[36355]=70; image[36356]=65; image[36357]=82; image[36358]=101; image[36359]=110; image[36360]=134; image[36361]=139; image[36362]=149; image[36363]=148; image[36364]=151; image[36365]=148; image[36366]=173; image[36367]=249; image[36368]=240; image[36369]=236; image[36370]=82; image[36371]=26; image[36372]=13; image[36373]=2; image[36374]=1; image[36375]=1; image[36376]=1; image[36377]=1; image[36378]=1; image[36379]=1; image[36380]=1; image[36381]=1; image[36382]=1; image[36383]=1; image[36384]=1; image[36385]=1; image[36386]=1; image[36387]=1; image[36388]=1; image[36389]=1; image[36390]=1; image[36391]=1; image[36392]=1; image[36393]=1; image[36394]=1; image[36395]=1; image[36396]=1; image[36397]=1; image[36398]=1; image[36399]=1; image[36400]=1; image[36401]=1; image[36402]=1; image[36403]=1; image[36404]=1; image[36405]=1; image[36406]=1; image[36407]=1; image[36408]=1; image[36409]=1; image[36410]=1; image[36411]=1; image[36412]=1; image[36413]=1; image[36414]=1; image[36415]=1; image[36416]=1; image[36417]=1; image[36418]=1; image[36419]=1; image[36420]=1; image[36421]=1; image[36422]=1; image[36423]=1; image[36424]=1; image[36425]=1; image[36426]=1; image[36427]=1; image[36428]=1; image[36429]=1; image[36430]=1; image[36431]=1; image[36432]=1; image[36433]=1; image[36434]=1; image[36435]=1; image[36436]=1; image[36437]=1; image[36438]=1; image[36439]=1; image[36440]=1; image[36441]=1; image[36442]=1; image[36443]=1; image[36444]=1; image[36445]=1; image[36446]=1; image[36447]=1; image[36448]=1; image[36449]=1; image[36450]=1; image[36451]=1; image[36452]=1; image[36453]=1; image[36454]=1; image[36455]=1; image[36456]=1; image[36457]=1; image[36458]=1; image[36459]=1; image[36460]=1; image[36461]=1; image[36462]=1; image[36463]=1; image[36464]=1; image[36465]=1; image[36466]=1; image[36467]=1; image[36468]=1; image[36469]=1; image[36470]=1; image[36471]=1; image[36472]=1; image[36473]=1; image[36474]=1; image[36475]=1; image[36476]=1; image[36477]=1; image[36478]=1; image[36479]=1; image[36480]=1; image[36481]=1; image[36482]=1; image[36483]=1; image[36484]=1; image[36485]=1; image[36486]=1; image[36487]=1; image[36488]=1; image[36489]=3; image[36490]=4; image[36491]=5; image[36492]=5; image[36493]=6; image[36494]=7; image[36495]=6; image[36496]=8; image[36497]=12; image[36498]=16; image[36499]=7; image[36500]=6; image[36501]=11; image[36502]=13; image[36503]=14; image[36504]=16; image[36505]=18; image[36506]=16; image[36507]=17; image[36508]=21; image[36509]=18; image[36510]=18; image[36511]=22; image[36512]=24; image[36513]=23; image[36514]=24; image[36515]=24; image[36516]=26; image[36517]=27; image[36518]=24; image[36519]=24; image[36520]=29; image[36521]=41; image[36522]=36; image[36523]=25; image[36524]=10; image[36525]=14; image[36526]=31; image[36527]=29; image[36528]=25; image[36529]=36; image[36530]=37; image[36531]=36; image[36532]=43; image[36533]=45; image[36534]=53; image[36535]=47; image[36536]=49; image[36537]=22; image[36538]=8; image[36539]=14; image[36540]=118; image[36541]=114; image[36542]=57; image[36543]=73; image[36544]=83; image[36545]=59; image[36546]=56; image[36547]=51; image[36548]=59; image[36549]=61; image[36550]=65; image[36551]=72; image[36552]=74; image[36553]=74; image[36554]=73; image[36555]=67; image[36556]=86; image[36557]=102; image[36558]=119; image[36559]=144; image[36560]=129; image[36561]=155; image[36562]=152; image[36563]=152; image[36564]=156; image[36565]=183; image[36566]=254; image[36567]=209; image[36568]=193; image[36569]=69; image[36570]=20; image[36571]=13; image[36572]=2; image[36573]=1; image[36574]=1; image[36575]=1; image[36576]=1; image[36577]=1; image[36578]=1; image[36579]=0; image[36580]=1; image[36581]=1; image[36582]=1; image[36583]=1; image[36584]=1; image[36585]=1; image[36586]=1; image[36587]=1; image[36588]=1; image[36589]=1; image[36590]=1; image[36591]=1; image[36592]=1; image[36593]=1; image[36594]=1; image[36595]=1; image[36596]=1; image[36597]=1; image[36598]=1; image[36599]=1; image[36600]=1; image[36601]=1; image[36602]=1; image[36603]=1; image[36604]=1; image[36605]=1; image[36606]=1; image[36607]=1; image[36608]=1; image[36609]=1; image[36610]=1; image[36611]=1; image[36612]=1; image[36613]=1; image[36614]=1; image[36615]=1; image[36616]=1; image[36617]=1; image[36618]=1; image[36619]=1; image[36620]=1; image[36621]=1; image[36622]=1; image[36623]=1; image[36624]=1; image[36625]=1; image[36626]=1; image[36627]=1; image[36628]=1; image[36629]=1; image[36630]=1; image[36631]=1; image[36632]=1; image[36633]=1; image[36634]=1; image[36635]=1; image[36636]=1; image[36637]=1; image[36638]=1; image[36639]=1; image[36640]=1; image[36641]=1; image[36642]=1; image[36643]=1; image[36644]=1; image[36645]=1; image[36646]=1; image[36647]=1; image[36648]=1; image[36649]=1; image[36650]=1; image[36651]=1; image[36652]=1; image[36653]=1; image[36654]=1; image[36655]=1; image[36656]=1; image[36657]=1; image[36658]=1; image[36659]=1; image[36660]=1; image[36661]=1; image[36662]=1; image[36663]=1; image[36664]=1; image[36665]=1; image[36666]=1; image[36667]=1; image[36668]=1; image[36669]=1; image[36670]=1; image[36671]=1; image[36672]=1; image[36673]=1; image[36674]=1; image[36675]=1; image[36676]=1; image[36677]=1; image[36678]=1; image[36679]=1; image[36680]=1; image[36681]=1; image[36682]=1; image[36683]=1; image[36684]=1; image[36685]=1; image[36686]=1; image[36687]=2; image[36688]=3; image[36689]=4; image[36690]=4; image[36691]=5; image[36692]=7; image[36693]=6; image[36694]=7; image[36695]=9; image[36696]=17; image[36697]=17; image[36698]=6; image[36699]=5; image[36700]=12; image[36701]=14; image[36702]=15; image[36703]=15; image[36704]=15; image[36705]=17; image[36706]=17; image[36707]=18; image[36708]=18; image[36709]=20; image[36710]=23; image[36711]=22; image[36712]=21; image[36713]=25; image[36714]=24; image[36715]=23; image[36716]=26; image[36717]=30; image[36718]=27; image[36719]=29; image[36720]=39; image[36721]=32; image[36722]=31; image[36723]=11; image[36724]=17; image[36725]=30; image[36726]=28; image[36727]=27; image[36728]=36; image[36729]=40; image[36730]=40; image[36731]=42; image[36732]=43; image[36733]=55; image[36734]=46; image[36735]=39; image[36736]=14; image[36737]=9; image[36738]=15; image[36739]=115; image[36740]=107; image[36741]=64; image[36742]=64; image[36743]=78; image[36744]=91; image[36745]=74; image[36746]=58; image[36747]=66; image[36748]=63; image[36749]=71; image[36750]=76; image[36751]=78; image[36752]=82; image[36753]=80; image[36754]=68; image[36755]=96; image[36756]=112; image[36757]=118; image[36758]=150; image[36759]=139; image[36760]=153; image[36761]=156; image[36762]=153; image[36763]=157; image[36764]=188; image[36765]=254; image[36766]=218; image[36767]=164; image[36768]=54; image[36769]=18; image[36770]=9; image[36771]=2; image[36772]=1; image[36773]=1; image[36774]=1; image[36775]=1; image[36776]=1; image[36777]=1; image[36778]=1; image[36779]=1; image[36780]=1; image[36781]=1; image[36782]=1; image[36783]=1; image[36784]=1; image[36785]=1; image[36786]=1; image[36787]=1; image[36788]=0; image[36789]=1; image[36790]=1; image[36791]=1; image[36792]=1; image[36793]=1; image[36794]=1; image[36795]=1; image[36796]=1; image[36797]=1; image[36798]=1; image[36799]=1; image[36800]=1; image[36801]=1; image[36802]=1; image[36803]=1; image[36804]=1; image[36805]=1; image[36806]=1; image[36807]=1; image[36808]=1; image[36809]=1; image[36810]=1; image[36811]=1; image[36812]=1; image[36813]=1; image[36814]=1; image[36815]=1; image[36816]=1; image[36817]=1; image[36818]=1; image[36819]=1; image[36820]=1; image[36821]=1; image[36822]=1; image[36823]=1; image[36824]=1; image[36825]=1; image[36826]=1; image[36827]=1; image[36828]=1; image[36829]=1; image[36830]=1; image[36831]=1; image[36832]=1; image[36833]=1; image[36834]=1; image[36835]=1; image[36836]=1; image[36837]=1; image[36838]=1; image[36839]=1; image[36840]=1; image[36841]=1; image[36842]=1; image[36843]=1; image[36844]=1; image[36845]=1; image[36846]=1; image[36847]=1; image[36848]=1; image[36849]=1; image[36850]=1; image[36851]=1; image[36852]=1; image[36853]=1; image[36854]=1; image[36855]=1; image[36856]=1; image[36857]=1; image[36858]=1; image[36859]=1; image[36860]=1; image[36861]=1; image[36862]=1; image[36863]=1; image[36864]=1; image[36865]=1; image[36866]=1; image[36867]=1; image[36868]=1; image[36869]=1; image[36870]=1; image[36871]=1; image[36872]=1; image[36873]=1; image[36874]=1; image[36875]=1; image[36876]=1; image[36877]=1; image[36878]=1; image[36879]=1; image[36880]=1; image[36881]=1; image[36882]=1; image[36883]=1; image[36884]=1; image[36885]=2; image[36886]=4; image[36887]=4; image[36888]=4; image[36889]=5; image[36890]=5; image[36891]=6; image[36892]=6; image[36893]=7; image[36894]=10; image[36895]=16; image[36896]=14; image[36897]=7; image[36898]=4; image[36899]=10; image[36900]=12; image[36901]=13; image[36902]=15; image[36903]=15; image[36904]=16; image[36905]=19; image[36906]=19; image[36907]=18; image[36908]=20; image[36909]=22; image[36910]=21; image[36911]=20; image[36912]=25; image[36913]=23; image[36914]=28; image[36915]=29; image[36916]=32; image[36917]=32; image[36918]=32; image[36919]=35; image[36920]=33; image[36921]=34; image[36922]=15; image[36923]=21; image[36924]=36; image[36925]=30; image[36926]=28; image[36927]=37; image[36928]=44; image[36929]=43; image[36930]=41; image[36931]=44; image[36932]=56; image[36933]=45; image[36934]=43; image[36935]=14; image[36936]=7; image[36937]=17; image[36938]=80; image[36939]=74; image[36940]=46; image[36941]=69; image[36942]=100; image[36943]=74; image[36944]=67; image[36945]=70; image[36946]=70; image[36947]=63; image[36948]=74; image[36949]=77; image[36950]=81; image[36951]=86; image[36952]=86; image[36953]=78; image[36954]=96; image[36955]=107; image[36956]=125; image[36957]=151; image[36958]=158; image[36959]=158; image[36960]=161; image[36961]=157; image[36962]=178; image[36963]=216; image[36964]=254; image[36965]=232; image[36966]=181; image[36967]=54; image[36968]=38; image[36969]=13; image[36970]=2; image[36971]=1; image[36972]=1; image[36973]=1; image[36974]=1; image[36975]=1; image[36976]=1; image[36977]=1; image[36978]=1; image[36979]=1; image[36980]=1; image[36981]=1; image[36982]=1; image[36983]=1; image[36984]=1; image[36985]=1; image[36986]=1; image[36987]=1; image[36988]=1; image[36989]=1; image[36990]=1; image[36991]=1; image[36992]=1; image[36993]=1; image[36994]=1; image[36995]=1; image[36996]=1; image[36997]=1; image[36998]=1; image[36999]=1; image[37000]=1; image[37001]=1; image[37002]=1; image[37003]=1; image[37004]=1; image[37005]=1; image[37006]=1; image[37007]=1; image[37008]=1; image[37009]=1; image[37010]=1; image[37011]=1; image[37012]=1; image[37013]=1; image[37014]=1; image[37015]=1; image[37016]=1; image[37017]=1; image[37018]=1; image[37019]=1; image[37020]=1; image[37021]=1; image[37022]=1; image[37023]=1; image[37024]=1; image[37025]=1; image[37026]=1; image[37027]=1; image[37028]=1; image[37029]=1; image[37030]=1; image[37031]=1; image[37032]=1; image[37033]=1; image[37034]=1; image[37035]=1; image[37036]=1; image[37037]=1; image[37038]=1; image[37039]=1; image[37040]=1; image[37041]=1; image[37042]=1; image[37043]=1; image[37044]=1; image[37045]=1; image[37046]=1; image[37047]=1; image[37048]=1; image[37049]=1; image[37050]=1; image[37051]=1; image[37052]=1; image[37053]=1; image[37054]=1; image[37055]=1; image[37056]=1; image[37057]=1; image[37058]=1; image[37059]=1; image[37060]=1; image[37061]=1; image[37062]=1; image[37063]=1; image[37064]=1; image[37065]=1; image[37066]=1; image[37067]=1; image[37068]=1; image[37069]=1; image[37070]=1; image[37071]=1; image[37072]=1; image[37073]=1; image[37074]=1; image[37075]=1; image[37076]=1; image[37077]=1; image[37078]=1; image[37079]=1; image[37080]=1; image[37081]=1; image[37082]=1; image[37083]=1; image[37084]=2; image[37085]=3; image[37086]=3; image[37087]=5; image[37088]=5; image[37089]=5; image[37090]=5; image[37091]=5; image[37092]=7; image[37093]=9; image[37094]=10; image[37095]=9; image[37096]=4; image[37097]=4; image[37098]=9; image[37099]=13; image[37100]=13; image[37101]=15; image[37102]=15; image[37103]=15; image[37104]=16; image[37105]=17; image[37106]=18; image[37107]=21; image[37108]=24; image[37109]=22; image[37110]=24; image[37111]=27; image[37112]=24; image[37113]=25; image[37114]=26; image[37115]=29; image[37116]=33; image[37117]=36; image[37118]=40; image[37119]=38; image[37120]=24; image[37121]=14; image[37122]=23; image[37123]=32; image[37124]=29; image[37125]=30; image[37126]=37; image[37127]=43; image[37128]=41; image[37129]=43; image[37130]=49; image[37131]=54; image[37132]=44; image[37133]=32; image[37134]=5; image[37135]=6; image[37136]=20; image[37137]=68; image[37138]=65; image[37139]=58; image[37140]=66; image[37141]=67; image[37142]=51; image[37143]=63; image[37144]=83; image[37145]=66; image[37146]=63; image[37147]=76; image[37148]=80; image[37149]=85; image[37150]=88; image[37151]=88; image[37152]=80; image[37153]=101; image[37154]=109; image[37155]=124; image[37156]=154; image[37157]=164; image[37158]=157; image[37159]=170; image[37160]=166; image[37161]=198; image[37162]=245; image[37163]=255; image[37164]=247; image[37165]=213; image[37166]=53; image[37167]=40; image[37168]=13; image[37169]=1; image[37170]=1; image[37171]=1; image[37172]=1; image[37173]=1; image[37174]=1; image[37175]=1; image[37176]=1; image[37177]=1; image[37178]=1; image[37179]=1; image[37180]=1; image[37181]=1; image[37182]=1; image[37183]=1; image[37184]=1; image[37185]=1; image[37186]=1; image[37187]=1; image[37188]=1; image[37189]=1; image[37190]=1; image[37191]=1; image[37192]=1; image[37193]=1; image[37194]=1; image[37195]=1; image[37196]=1; image[37197]=1; image[37198]=1; image[37199]=1; image[37200]=1; image[37201]=1; image[37202]=1; image[37203]=1; image[37204]=1; image[37205]=1; image[37206]=1; image[37207]=1; image[37208]=0; image[37209]=1; image[37210]=1; image[37211]=1; image[37212]=1; image[37213]=1; image[37214]=1; image[37215]=1; image[37216]=1; image[37217]=1; image[37218]=1; image[37219]=1; image[37220]=1; image[37221]=1; image[37222]=1; image[37223]=1; image[37224]=1; image[37225]=1; image[37226]=1; image[37227]=1; image[37228]=1; image[37229]=1; image[37230]=1; image[37231]=1; image[37232]=1; image[37233]=1; image[37234]=1; image[37235]=1; image[37236]=1; image[37237]=1; image[37238]=1; image[37239]=1; image[37240]=1; image[37241]=1; image[37242]=1; image[37243]=1; image[37244]=1; image[37245]=1; image[37246]=1; image[37247]=1; image[37248]=1; image[37249]=1; image[37250]=1; image[37251]=1; image[37252]=1; image[37253]=1; image[37254]=1; image[37255]=1; image[37256]=1; image[37257]=1; image[37258]=1; image[37259]=1; image[37260]=1; image[37261]=1; image[37262]=1; image[37263]=1; image[37264]=1; image[37265]=1; image[37266]=1; image[37267]=1; image[37268]=1; image[37269]=1; image[37270]=1; image[37271]=1; image[37272]=1; image[37273]=1; image[37274]=1; image[37275]=1; image[37276]=1; image[37277]=1; image[37278]=1; image[37279]=1; image[37280]=1; image[37281]=2; image[37282]=2; image[37283]=2; image[37284]=3; image[37285]=4; image[37286]=4; image[37287]=4; image[37288]=6; image[37289]=6; image[37290]=5; image[37291]=7; image[37292]=7; image[37293]=5; image[37294]=5; image[37295]=3; image[37296]=6; image[37297]=12; image[37298]=14; image[37299]=15; image[37300]=16; image[37301]=17; image[37302]=16; image[37303]=16; image[37304]=16; image[37305]=20; image[37306]=25; image[37307]=26; image[37308]=22; image[37309]=21; image[37310]=21; image[37311]=24; image[37312]=28; image[37313]=27; image[37314]=30; image[37315]=36; image[37316]=38; image[37317]=39; image[37318]=47; image[37319]=33; image[37320]=16; image[37321]=28; image[37322]=34; image[37323]=30; image[37324]=34; image[37325]=43; image[37326]=41; image[37327]=44; image[37328]=48; image[37329]=46; image[37330]=45; image[37331]=38; image[37332]=18; image[37333]=2; image[37334]=5; image[37335]=24; image[37336]=126; image[37337]=84; image[37338]=49; image[37339]=58; image[37340]=65; image[37341]=60; image[37342]=71; image[37343]=81; image[37344]=62; image[37345]=73; image[37346]=78; image[37347]=79; image[37348]=87; image[37349]=91; image[37350]=83; image[37351]=90; image[37352]=109; image[37353]=121; image[37354]=132; image[37355]=159; image[37356]=157; image[37357]=168; image[37358]=168; image[37359]=158; image[37360]=194; image[37361]=248; image[37362]=255; image[37363]=255; image[37364]=196; image[37365]=43; image[37366]=27; image[37367]=7; image[37368]=1; image[37369]=1; image[37370]=1; image[37371]=1; image[37372]=1; image[37373]=1; image[37374]=1; image[37375]=1; image[37376]=1; image[37377]=1; image[37378]=1; image[37379]=1; image[37380]=1; image[37381]=1; image[37382]=1; image[37383]=1; image[37384]=1; image[37385]=1; image[37386]=1; image[37387]=1; image[37388]=1; image[37389]=1; image[37390]=1; image[37391]=1; image[37392]=1; image[37393]=1; image[37394]=1; image[37395]=1; image[37396]=1; image[37397]=1; image[37398]=1; image[37399]=1; image[37400]=1; image[37401]=1; image[37402]=1; image[37403]=1; image[37404]=1; image[37405]=1; image[37406]=1; image[37407]=1; image[37408]=1; image[37409]=1; image[37410]=1; image[37411]=1; image[37412]=1; image[37413]=1; image[37414]=1; image[37415]=1; image[37416]=1; image[37417]=1; image[37418]=1; image[37419]=1; image[37420]=1; image[37421]=1; image[37422]=1; image[37423]=1; image[37424]=1; image[37425]=1; image[37426]=1; image[37427]=1; image[37428]=1; image[37429]=1; image[37430]=1; image[37431]=1; image[37432]=1; image[37433]=1; image[37434]=1; image[37435]=1; image[37436]=1; image[37437]=1; image[37438]=1; image[37439]=1; image[37440]=1; image[37441]=1; image[37442]=1; image[37443]=1; image[37444]=1; image[37445]=1; image[37446]=1; image[37447]=1; image[37448]=1; image[37449]=1; image[37450]=1; image[37451]=1; image[37452]=1; image[37453]=1; image[37454]=1; image[37455]=1; image[37456]=1; image[37457]=1; image[37458]=1; image[37459]=1; image[37460]=1; image[37461]=1; image[37462]=1; image[37463]=1; image[37464]=1; image[37465]=1; image[37466]=1; image[37467]=1; image[37468]=1; image[37469]=1; image[37470]=1; image[37471]=1; image[37472]=1; image[37473]=1; image[37474]=1; image[37475]=1; image[37476]=1; image[37477]=1; image[37478]=1; image[37479]=1; image[37480]=1; image[37481]=2; image[37482]=3; image[37483]=4; image[37484]=4; image[37485]=4; image[37486]=4; image[37487]=5; image[37488]=5; image[37489]=5; image[37490]=7; image[37491]=4; image[37492]=3; image[37493]=4; image[37494]=4; image[37495]=8; image[37496]=13; image[37497]=15; image[37498]=16; image[37499]=16; image[37500]=17; image[37501]=18; image[37502]=17; image[37503]=18; image[37504]=20; image[37505]=21; image[37506]=23; image[37507]=21; image[37508]=23; image[37509]=21; image[37510]=24; image[37511]=27; image[37512]=29; image[37513]=28; image[37514]=28; image[37515]=31; image[37516]=29; image[37517]=31; image[37518]=24; image[37519]=20; image[37520]=36; image[37521]=37; image[37522]=32; image[37523]=39; image[37524]=41; image[37525]=40; image[37526]=54; image[37527]=55; image[37528]=53; image[37529]=47; image[37530]=35; image[37531]=9; image[37532]=1; image[37533]=1; image[37534]=15; image[37535]=106; image[37536]=96; image[37537]=60; image[37538]=63; image[37539]=68; image[37540]=68; image[37541]=70; image[37542]=68; image[37543]=66; image[37544]=82; image[37545]=73; image[37546]=83; image[37547]=94; image[37548]=88; image[37549]=77; image[37550]=91; image[37551]=112; image[37552]=131; image[37553]=139; image[37554]=154; image[37555]=165; image[37556]=182; image[37557]=154; image[37558]=153; image[37559]=213; image[37560]=251; image[37561]=255; image[37562]=255; image[37563]=178; image[37564]=35; image[37565]=25; image[37566]=5; image[37567]=1; image[37568]=1; image[37569]=1; image[37570]=1; image[37571]=1; image[37572]=1; image[37573]=1; image[37574]=1; image[37575]=1; image[37576]=1; image[37577]=1; image[37578]=1; image[37579]=1; image[37580]=1; image[37581]=1; image[37582]=1; image[37583]=1; image[37584]=1; image[37585]=1; image[37586]=1; image[37587]=1; image[37588]=1; image[37589]=1; image[37590]=1; image[37591]=1; image[37592]=1; image[37593]=1; image[37594]=1; image[37595]=1; image[37596]=1; image[37597]=1; image[37598]=1; image[37599]=1; image[37600]=1; image[37601]=1; image[37602]=1; image[37603]=1; image[37604]=1; image[37605]=1; image[37606]=1; image[37607]=1; image[37608]=1; image[37609]=1; image[37610]=1; image[37611]=1; image[37612]=1; image[37613]=1; image[37614]=1; image[37615]=0; image[37616]=0; image[37617]=1; image[37618]=1; image[37619]=1; image[37620]=1; image[37621]=1; image[37622]=1; image[37623]=1; image[37624]=1; image[37625]=1; image[37626]=1; image[37627]=1; image[37628]=1; image[37629]=1; image[37630]=1; image[37631]=1; image[37632]=1; image[37633]=1; image[37634]=1; image[37635]=1; image[37636]=1; image[37637]=1; image[37638]=1; image[37639]=1; image[37640]=1; image[37641]=1; image[37642]=1; image[37643]=1; image[37644]=1; image[37645]=1; image[37646]=1; image[37647]=1; image[37648]=1; image[37649]=1; image[37650]=1; image[37651]=1; image[37652]=1; image[37653]=1; image[37654]=1; image[37655]=1; image[37656]=1; image[37657]=1; image[37658]=1; image[37659]=1; image[37660]=1; image[37661]=1; image[37662]=1; image[37663]=1; image[37664]=1; image[37665]=1; image[37666]=1; image[37667]=1; image[37668]=1; image[37669]=1; image[37670]=1; image[37671]=1; image[37672]=1; image[37673]=1; image[37674]=1; image[37675]=1; image[37676]=1; image[37677]=1; image[37678]=2; image[37679]=2; image[37680]=2; image[37681]=3; image[37682]=4; image[37683]=3; image[37684]=4; image[37685]=4; image[37686]=6; image[37687]=5; image[37688]=5; image[37689]=6; image[37690]=4; image[37691]=3; image[37692]=2; image[37693]=4; image[37694]=11; image[37695]=13; image[37696]=16; image[37697]=15; image[37698]=15; image[37699]=18; image[37700]=17; image[37701]=18; image[37702]=19; image[37703]=20; image[37704]=20; image[37705]=23; image[37706]=20; image[37707]=20; image[37708]=19; image[37709]=23; image[37710]=27; image[37711]=34; image[37712]=37; image[37713]=40; image[37714]=32; image[37715]=28; image[37716]=33; image[37717]=30; image[37718]=31; image[37719]=38; image[37720]=39; image[37721]=32; image[37722]=38; image[37723]=36; image[37724]=43; image[37725]=60; image[37726]=55; image[37727]=64; image[37728]=57; image[37729]=28; image[37730]=6; image[37731]=10; image[37732]=3; image[37733]=13; image[37734]=85; image[37735]=129; image[37736]=95; image[37737]=63; image[37738]=67; image[37739]=79; image[37740]=74; image[37741]=81; image[37742]=81; image[37743]=85; image[37744]=72; image[37745]=80; image[37746]=96; image[37747]=83; image[37748]=72; image[37749]=91; image[37750]=116; image[37751]=135; image[37752]=154; image[37753]=157; image[37754]=172; image[37755]=199; image[37756]=174; image[37757]=165; image[37758]=231; image[37759]=255; image[37760]=255; image[37761]=255; image[37762]=183; image[37763]=37; image[37764]=24; image[37765]=4; image[37766]=1; image[37767]=1; image[37768]=1; image[37769]=1; image[37770]=1; image[37771]=1; image[37772]=1; image[37773]=1; image[37774]=1; image[37775]=1; image[37776]=1; image[37777]=1; image[37778]=1; image[37779]=1; image[37780]=1; image[37781]=1; image[37782]=1; image[37783]=1; image[37784]=1; image[37785]=1; image[37786]=1; image[37787]=1; image[37788]=1; image[37789]=1; image[37790]=1; image[37791]=1; image[37792]=1; image[37793]=1; image[37794]=1; image[37795]=1; image[37796]=1; image[37797]=1; image[37798]=1; image[37799]=1; image[37800]=1; image[37801]=1; image[37802]=1; image[37803]=1; image[37804]=1; image[37805]=1; image[37806]=1; image[37807]=1; image[37808]=1; image[37809]=1; image[37810]=1; image[37811]=1; image[37812]=1; image[37813]=1; image[37814]=1; image[37815]=1; image[37816]=1; image[37817]=1; image[37818]=1; image[37819]=1; image[37820]=1; image[37821]=1; image[37822]=1; image[37823]=1; image[37824]=1; image[37825]=1; image[37826]=1; image[37827]=1; image[37828]=1; image[37829]=1; image[37830]=1; image[37831]=1; image[37832]=1; image[37833]=1; image[37834]=1; image[37835]=1; image[37836]=1; image[37837]=1; image[37838]=1; image[37839]=1; image[37840]=1; image[37841]=1; image[37842]=1; image[37843]=1; image[37844]=1; image[37845]=1; image[37846]=1; image[37847]=1; image[37848]=1; image[37849]=1; image[37850]=1; image[37851]=1; image[37852]=1; image[37853]=1; image[37854]=1; image[37855]=1; image[37856]=1; image[37857]=1; image[37858]=1; image[37859]=1; image[37860]=1; image[37861]=1; image[37862]=1; image[37863]=1; image[37864]=1; image[37865]=1; image[37866]=1; image[37867]=1; image[37868]=1; image[37869]=1; image[37870]=1; image[37871]=1; image[37872]=1; image[37873]=1; image[37874]=1; image[37875]=1; image[37876]=1; image[37877]=1; image[37878]=2; image[37879]=2; image[37880]=3; image[37881]=3; image[37882]=3; image[37883]=4; image[37884]=4; image[37885]=5; image[37886]=6; image[37887]=7; image[37888]=7; image[37889]=8; image[37890]=5; image[37891]=3; image[37892]=7; image[37893]=12; image[37894]=13; image[37895]=13; image[37896]=16; image[37897]=18; image[37898]=19; image[37899]=17; image[37900]=18; image[37901]=17; image[37902]=19; image[37903]=23; image[37904]=25; image[37905]=23; image[37906]=20; image[37907]=22; image[37908]=26; image[37909]=28; image[37910]=28; image[37911]=32; image[37912]=43; image[37913]=51; image[37914]=48; image[37915]=38; image[37916]=25; image[37917]=34; image[37918]=36; image[37919]=34; image[37920]=29; image[37921]=36; image[37922]=37; image[37923]=45; image[37924]=56; image[37925]=55; image[37926]=59; image[37927]=53; image[37928]=22; image[37929]=7; image[37930]=47; image[37931]=16; image[37932]=9; image[37933]=52; image[37934]=133; image[37935]=107; image[37936]=60; image[37937]=62; image[37938]=65; image[37939]=65; image[37940]=81; image[37941]=80; image[37942]=81; image[37943]=81; image[37944]=88; image[37945]=101; image[37946]=81; image[37947]=68; image[37948]=98; image[37949]=119; image[37950]=137; image[37951]=161; image[37952]=162; image[37953]=175; image[37954]=197; image[37955]=187; image[37956]=188; image[37957]=236; image[37958]=255; image[37959]=213; image[37960]=243; image[37961]=170; image[37962]=33; image[37963]=25; image[37964]=3; image[37965]=1; image[37966]=1; image[37967]=1; image[37968]=1; image[37969]=1; image[37970]=1; image[37971]=1; image[37972]=1; image[37973]=1; image[37974]=1; image[37975]=1; image[37976]=1; image[37977]=1; image[37978]=1; image[37979]=1; image[37980]=1; image[37981]=1; image[37982]=1; image[37983]=1; image[37984]=1; image[37985]=1; image[37986]=1; image[37987]=1; image[37988]=1; image[37989]=1; image[37990]=1; image[37991]=1; image[37992]=1; image[37993]=1; image[37994]=1; image[37995]=1; image[37996]=1; image[37997]=1; image[37998]=1; image[37999]=1; image[38000]=1; image[38001]=1; image[38002]=1; image[38003]=1; image[38004]=1; image[38005]=1; image[38006]=1; image[38007]=1; image[38008]=1; image[38009]=1; image[38010]=1; image[38011]=1; image[38012]=1; image[38013]=1; image[38014]=1; image[38015]=1; image[38016]=1; image[38017]=1; image[38018]=1; image[38019]=1; image[38020]=1; image[38021]=1; image[38022]=1; image[38023]=1; image[38024]=1; image[38025]=1; image[38026]=1; image[38027]=1; image[38028]=1; image[38029]=1; image[38030]=1; image[38031]=1; image[38032]=1; image[38033]=1; image[38034]=1; image[38035]=1; image[38036]=1; image[38037]=1; image[38038]=1; image[38039]=1; image[38040]=1; image[38041]=1; image[38042]=1; image[38043]=1; image[38044]=1; image[38045]=1; image[38046]=1; image[38047]=1; image[38048]=1; image[38049]=1; image[38050]=1; image[38051]=1; image[38052]=1; image[38053]=1; image[38054]=1; image[38055]=1; image[38056]=1; image[38057]=1; image[38058]=1; image[38059]=1; image[38060]=1; image[38061]=1; image[38062]=1; image[38063]=1; image[38064]=1; image[38065]=1; image[38066]=1; image[38067]=1; image[38068]=1; image[38069]=1; image[38070]=1; image[38071]=1; image[38072]=1; image[38073]=1; image[38074]=1; image[38075]=1; image[38076]=2; image[38077]=2; image[38078]=2; image[38079]=3; image[38080]=3; image[38081]=3; image[38082]=4; image[38083]=4; image[38084]=4; image[38085]=7; image[38086]=8; image[38087]=10; image[38088]=12; image[38089]=5; image[38090]=4; image[38091]=8; image[38092]=10; image[38093]=13; image[38094]=15; image[38095]=16; image[38096]=18; image[38097]=19; image[38098]=18; image[38099]=18; image[38100]=20; image[38101]=20; image[38102]=24; image[38103]=21; image[38104]=22; image[38105]=24; image[38106]=28; image[38107]=30; image[38108]=31; image[38109]=31; image[38110]=29; image[38111]=29; image[38112]=41; image[38113]=49; image[38114]=46; image[38115]=25; image[38116]=30; image[38117]=39; image[38118]=35; image[38119]=33; image[38120]=43; image[38121]=43; image[38122]=47; image[38123]=54; image[38124]=57; image[38125]=62; image[38126]=55; image[38127]=28; image[38128]=6; image[38129]=72; image[38130]=50; image[38131]=9; image[38132]=28; image[38133]=104; image[38134]=104; image[38135]=69; image[38136]=76; image[38137]=73; image[38138]=70; image[38139]=78; image[38140]=82; image[38141]=86; image[38142]=81; image[38143]=89; image[38144]=92; image[38145]=77; image[38146]=72; image[38147]=105; image[38148]=136; image[38149]=142; image[38150]=146; image[38151]=167; image[38152]=190; image[38153]=209; image[38154]=201; image[38155]=216; image[38156]=243; image[38157]=255; image[38158]=255; image[38159]=252; image[38160]=126; image[38161]=21; image[38162]=20; image[38163]=2; image[38164]=1; image[38165]=1; image[38166]=1; image[38167]=1; image[38168]=1; image[38169]=1; image[38170]=1; image[38171]=1; image[38172]=1; image[38173]=1; image[38174]=1; image[38175]=1; image[38176]=1; image[38177]=1; image[38178]=1; image[38179]=1; image[38180]=1; image[38181]=1; image[38182]=1; image[38183]=1; image[38184]=1; image[38185]=1; image[38186]=1; image[38187]=1; image[38188]=1; image[38189]=1; image[38190]=1; image[38191]=1; image[38192]=1; image[38193]=1; image[38194]=1; image[38195]=1; image[38196]=1; image[38197]=1; image[38198]=1; image[38199]=1; image[38200]=1; image[38201]=1; image[38202]=1; image[38203]=1; image[38204]=1; image[38205]=1; image[38206]=1; image[38207]=1; image[38208]=1; image[38209]=1; image[38210]=1; image[38211]=1; image[38212]=1; image[38213]=1; image[38214]=1; image[38215]=1; image[38216]=1; image[38217]=1; image[38218]=1; image[38219]=1; image[38220]=1; image[38221]=1; image[38222]=1; image[38223]=1; image[38224]=1; image[38225]=1; image[38226]=1; image[38227]=1; image[38228]=1; image[38229]=1; image[38230]=1; image[38231]=1; image[38232]=1; image[38233]=1; image[38234]=1; image[38235]=1; image[38236]=1; image[38237]=1; image[38238]=1; image[38239]=1; image[38240]=1; image[38241]=1; image[38242]=1; image[38243]=1; image[38244]=1; image[38245]=1; image[38246]=1; image[38247]=1; image[38248]=1; image[38249]=1; image[38250]=1; image[38251]=1; image[38252]=1; image[38253]=1; image[38254]=1; image[38255]=1; image[38256]=1; image[38257]=1; image[38258]=1; image[38259]=1; image[38260]=1; image[38261]=1; image[38262]=1; image[38263]=1; image[38264]=1; image[38265]=1; image[38266]=1; image[38267]=1; image[38268]=1; image[38269]=1; image[38270]=1; image[38271]=1; image[38272]=1; image[38273]=1; image[38274]=1; image[38275]=2; image[38276]=2; image[38277]=3; image[38278]=2; image[38279]=3; image[38280]=3; image[38281]=4; image[38282]=4; image[38283]=5; image[38284]=7; image[38285]=7; image[38286]=13; image[38287]=7; image[38288]=2; image[38289]=7; image[38290]=8; image[38291]=11; image[38292]=13; image[38293]=14; image[38294]=15; image[38295]=17; image[38296]=18; image[38297]=20; image[38298]=20; image[38299]=19; image[38300]=19; image[38301]=21; image[38302]=22; image[38303]=23; image[38304]=22; image[38305]=25; image[38306]=27; image[38307]=27; image[38308]=30; image[38309]=32; image[38310]=34; image[38311]=37; image[38312]=29; image[38313]=29; image[38314]=25; image[38315]=29; image[38316]=37; image[38317]=35; image[38318]=36; image[38319]=48; image[38320]=50; image[38321]=48; image[38322]=44; image[38323]=53; image[38324]=60; image[38325]=54; image[38326]=30; image[38327]=8; image[38328]=61; image[38329]=57; image[38330]=17; image[38331]=24; image[38332]=68; image[38333]=84; image[38334]=74; image[38335]=73; image[38336]=63; image[38337]=78; image[38338]=86; image[38339]=81; image[38340]=89; image[38341]=82; image[38342]=95; image[38343]=86; image[38344]=73; image[38345]=72; image[38346]=100; image[38347]=127; image[38348]=144; image[38349]=164; image[38350]=184; image[38351]=196; image[38352]=210; image[38353]=199; image[38354]=241; image[38355]=251; image[38356]=255; image[38357]=255; image[38358]=245; image[38359]=103; image[38360]=32; image[38361]=15; image[38362]=2; image[38363]=1; image[38364]=1; image[38365]=1; image[38366]=1; image[38367]=1; image[38368]=1; image[38369]=1; image[38370]=1; image[38371]=1; image[38372]=1; image[38373]=1; image[38374]=1; image[38375]=1; image[38376]=0; image[38377]=1; image[38378]=1; image[38379]=1; image[38380]=1; image[38381]=1; image[38382]=1; image[38383]=1; image[38384]=1; image[38385]=1; image[38386]=1; image[38387]=1; image[38388]=1; image[38389]=1; image[38390]=1; image[38391]=1; image[38392]=1; image[38393]=1; image[38394]=1; image[38395]=1; image[38396]=1; image[38397]=1; image[38398]=1; image[38399]=1; image[38400]=1; image[38401]=1; image[38402]=1; image[38403]=1; image[38404]=1; image[38405]=1; image[38406]=1; image[38407]=1; image[38408]=1; image[38409]=1; image[38410]=1; image[38411]=1; image[38412]=1; image[38413]=1; image[38414]=1; image[38415]=1; image[38416]=1; image[38417]=1; image[38418]=1; image[38419]=1; image[38420]=1; image[38421]=1; image[38422]=1; image[38423]=1; image[38424]=1; image[38425]=1; image[38426]=1; image[38427]=1; image[38428]=1; image[38429]=1; image[38430]=1; image[38431]=1; image[38432]=1; image[38433]=1; image[38434]=1; image[38435]=1; image[38436]=1; image[38437]=1; image[38438]=1; image[38439]=1; image[38440]=1; image[38441]=1; image[38442]=1; image[38443]=1; image[38444]=1; image[38445]=1; image[38446]=1; image[38447]=1; image[38448]=1; image[38449]=1; image[38450]=1; image[38451]=1; image[38452]=1; image[38453]=1; image[38454]=1; image[38455]=1; image[38456]=1; image[38457]=1; image[38458]=1; image[38459]=1; image[38460]=1; image[38461]=1; image[38462]=1; image[38463]=1; image[38464]=1; image[38465]=1; image[38466]=1; image[38467]=1; image[38468]=1; image[38469]=1; image[38470]=1; image[38471]=1; image[38472]=1; image[38473]=1; image[38474]=2; image[38475]=3; image[38476]=3; image[38477]=3; image[38478]=3; image[38479]=3; image[38480]=3; image[38481]=4; image[38482]=5; image[38483]=7; image[38484]=11; image[38485]=12; image[38486]=4; image[38487]=3; image[38488]=7; image[38489]=9; image[38490]=10; image[38491]=10; image[38492]=12; image[38493]=14; image[38494]=15; image[38495]=17; image[38496]=19; image[38497]=20; image[38498]=20; image[38499]=20; image[38500]=21; image[38501]=22; image[38502]=23; image[38503]=24; image[38504]=24; image[38505]=25; image[38506]=28; image[38507]=31; image[38508]=32; image[38509]=36; image[38510]=37; image[38511]=33; image[38512]=22; image[38513]=26; image[38514]=39; image[38515]=40; image[38516]=39; image[38517]=39; image[38518]=47; image[38519]=41; image[38520]=44; image[38521]=40; image[38522]=46; image[38523]=51; image[38524]=46; image[38525]=27; image[38526]=6; image[38527]=47; image[38528]=76; image[38529]=46; image[38530]=30; image[38531]=67; image[38532]=76; image[38533]=69; image[38534]=72; image[38535]=73; image[38536]=88; image[38537]=89; image[38538]=89; image[38539]=93; image[38540]=90; image[38541]=96; image[38542]=81; image[38543]=72; image[38544]=71; image[38545]=107; image[38546]=127; image[38547]=142; image[38548]=156; image[38549]=186; image[38550]=211; image[38551]=233; image[38552]=217; image[38553]=250; image[38554]=251; image[38555]=255; image[38556]=252; image[38557]=241; image[38558]=90; image[38559]=37; image[38560]=12; image[38561]=1; image[38562]=1; image[38563]=1; image[38564]=1; image[38565]=1; image[38566]=1; image[38567]=1; image[38568]=1; image[38569]=1; image[38570]=1; image[38571]=1; image[38572]=1; image[38573]=1; image[38574]=1; image[38575]=1; image[38576]=1; image[38577]=1; image[38578]=1; image[38579]=1; image[38580]=1; image[38581]=1; image[38582]=1; image[38583]=1; image[38584]=1; image[38585]=1; image[38586]=1; image[38587]=1; image[38588]=1; image[38589]=1; image[38590]=1; image[38591]=1; image[38592]=1; image[38593]=1; image[38594]=1; image[38595]=1; image[38596]=1; image[38597]=1; image[38598]=1; image[38599]=1; image[38600]=1; image[38601]=1; image[38602]=1; image[38603]=1; image[38604]=1; image[38605]=1; image[38606]=1; image[38607]=1; image[38608]=1; image[38609]=1; image[38610]=1; image[38611]=1; image[38612]=1; image[38613]=1; image[38614]=1; image[38615]=1; image[38616]=1; image[38617]=1; image[38618]=1; image[38619]=1; image[38620]=1; image[38621]=1; image[38622]=1; image[38623]=1; image[38624]=1; image[38625]=1; image[38626]=1; image[38627]=1; image[38628]=1; image[38629]=1; image[38630]=1; image[38631]=1; image[38632]=1; image[38633]=1; image[38634]=1; image[38635]=1; image[38636]=1; image[38637]=1; image[38638]=1; image[38639]=1; image[38640]=1; image[38641]=1; image[38642]=1; image[38643]=1; image[38644]=1; image[38645]=1; image[38646]=1; image[38647]=1; image[38648]=1; image[38649]=1; image[38650]=1; image[38651]=1; image[38652]=1; image[38653]=1; image[38654]=1; image[38655]=1; image[38656]=1; image[38657]=1; image[38658]=1; image[38659]=1; image[38660]=1; image[38661]=1; image[38662]=1; image[38663]=1; image[38664]=1; image[38665]=1; image[38666]=1; image[38667]=1; image[38668]=1; image[38669]=1; image[38670]=1; image[38671]=1; image[38672]=1; image[38673]=2; image[38674]=2; image[38675]=2; image[38676]=3; image[38677]=3; image[38678]=2; image[38679]=4; image[38680]=4; image[38681]=7; image[38682]=9; image[38683]=11; image[38684]=6; image[38685]=3; image[38686]=3; image[38687]=5; image[38688]=7; image[38689]=8; image[38690]=10; image[38691]=12; image[38692]=11; image[38693]=11; image[38694]=15; image[38695]=16; image[38696]=18; image[38697]=21; image[38698]=20; image[38699]=21; image[38700]=21; image[38701]=19; image[38702]=23; image[38703]=25; image[38704]=25; image[38705]=27; image[38706]=29; image[38707]=31; image[38708]=32; image[38709]=30; image[38710]=32; image[38711]=24; image[38712]=28; image[38713]=45; image[38714]=38; image[38715]=32; image[38716]=33; image[38717]=43; image[38718]=40; image[38719]=44; image[38720]=45; image[38721]=49; image[38722]=52; image[38723]=36; image[38724]=24; image[38725]=8; image[38726]=28; image[38727]=80; image[38728]=57; image[38729]=42; image[38730]=84; image[38731]=77; image[38732]=71; image[38733]=74; image[38734]=83; image[38735]=96; image[38736]=88; image[38737]=89; image[38738]=94; image[38739]=105; image[38740]=96; image[38741]=78; image[38742]=88; image[38743]=75; image[38744]=106; image[38745]=134; image[38746]=156; image[38747]=166; image[38748]=195; image[38749]=212; image[38750]=242; image[38751]=223; image[38752]=244; image[38753]=248; image[38754]=255; image[38755]=249; image[38756]=234; image[38757]=52; image[38758]=28; image[38759]=8; image[38760]=1; image[38761]=1; image[38762]=1; image[38763]=1; image[38764]=1; image[38765]=1; image[38766]=1; image[38767]=1; image[38768]=1; image[38769]=1; image[38770]=1; image[38771]=1; image[38772]=1; image[38773]=1; image[38774]=1; image[38775]=1; image[38776]=1; image[38777]=1; image[38778]=1; image[38779]=1; image[38780]=1; image[38781]=1; image[38782]=1; image[38783]=1; image[38784]=1; image[38785]=1; image[38786]=1; image[38787]=1; image[38788]=1; image[38789]=1; image[38790]=1; image[38791]=1; image[38792]=1; image[38793]=1; image[38794]=1; image[38795]=1; image[38796]=1; image[38797]=1; image[38798]=1; image[38799]=1; image[38800]=1; image[38801]=1; image[38802]=1; image[38803]=1; image[38804]=1; image[38805]=1; image[38806]=1; image[38807]=1; image[38808]=1; image[38809]=1; image[38810]=1; image[38811]=1; image[38812]=1; image[38813]=1; image[38814]=1; image[38815]=1; image[38816]=1; image[38817]=1; image[38818]=1; image[38819]=1; image[38820]=1; image[38821]=1; image[38822]=1; image[38823]=1; image[38824]=1; image[38825]=1; image[38826]=1; image[38827]=1; image[38828]=1; image[38829]=1; image[38830]=1; image[38831]=1; image[38832]=1; image[38833]=1; image[38834]=1; image[38835]=1; image[38836]=1; image[38837]=1; image[38838]=1; image[38839]=1; image[38840]=1; image[38841]=1; image[38842]=1; image[38843]=1; image[38844]=1; image[38845]=1; image[38846]=1; image[38847]=1; image[38848]=1; image[38849]=1; image[38850]=1; image[38851]=1; image[38852]=1; image[38853]=1; image[38854]=1; image[38855]=1; image[38856]=1; image[38857]=1; image[38858]=1; image[38859]=1; image[38860]=1; image[38861]=1; image[38862]=1; image[38863]=1; image[38864]=1; image[38865]=1; image[38866]=1; image[38867]=1; image[38868]=1; image[38869]=1; image[38870]=1; image[38871]=1; image[38872]=2; image[38873]=2; image[38874]=2; image[38875]=3; image[38876]=2; image[38877]=3; image[38878]=3; image[38879]=5; image[38880]=7; image[38881]=10; image[38882]=9; image[38883]=3; image[38884]=2; image[38885]=3; image[38886]=4; image[38887]=6; image[38888]=7; image[38889]=8; image[38890]=10; image[38891]=12; image[38892]=14; image[38893]=15; image[38894]=15; image[38895]=13; image[38896]=13; image[38897]=15; image[38898]=16; image[38899]=16; image[38900]=17; image[38901]=18; image[38902]=21; image[38903]=21; image[38904]=24; image[38905]=29; image[38906]=31; image[38907]=30; image[38908]=33; image[38909]=35; image[38910]=20; image[38911]=20; image[38912]=47; image[38913]=37; image[38914]=31; image[38915]=39; image[38916]=44; image[38917]=37; image[38918]=41; image[38919]=50; image[38920]=57; image[38921]=62; image[38922]=31; image[38923]=17; image[38924]=10; image[38925]=20; image[38926]=78; image[38927]=63; image[38928]=47; image[38929]=77; image[38930]=70; image[38931]=63; image[38932]=70; image[38933]=86; image[38934]=92; image[38935]=91; image[38936]=99; image[38937]=95; image[38938]=95; image[38939]=89; image[38940]=82; image[38941]=91; image[38942]=83; image[38943]=108; image[38944]=140; image[38945]=162; image[38946]=178; image[38947]=207; image[38948]=218; image[38949]=247; image[38950]=235; image[38951]=248; image[38952]=247; image[38953]=255; image[38954]=255; image[38955]=225; image[38956]=45; image[38957]=19; image[38958]=4; image[38959]=2; image[38960]=1; image[38961]=1; image[38962]=1; image[38963]=1; image[38964]=1; image[38965]=1; image[38966]=1; image[38967]=1; image[38968]=1; image[38969]=1; image[38970]=1; image[38971]=1; image[38972]=1; image[38973]=1; image[38974]=1; image[38975]=1; image[38976]=1; image[38977]=1; image[38978]=1; image[38979]=1; image[38980]=1; image[38981]=1; image[38982]=1; image[38983]=1; image[38984]=1; image[38985]=1; image[38986]=1; image[38987]=1; image[38988]=1; image[38989]=1; image[38990]=1; image[38991]=1; image[38992]=1; image[38993]=1; image[38994]=1; image[38995]=1; image[38996]=1; image[38997]=1; image[38998]=1; image[38999]=1; image[39000]=1; image[39001]=1; image[39002]=1; image[39003]=1; image[39004]=1; image[39005]=1; image[39006]=1; image[39007]=1; image[39008]=1; image[39009]=1; image[39010]=1; image[39011]=1; image[39012]=1; image[39013]=1; image[39014]=1; image[39015]=1; image[39016]=1; image[39017]=1; image[39018]=1; image[39019]=1; image[39020]=1; image[39021]=1; image[39022]=1; image[39023]=1; image[39024]=1; image[39025]=1; image[39026]=1; image[39027]=1; image[39028]=1; image[39029]=1; image[39030]=1; image[39031]=1; image[39032]=1; image[39033]=1; image[39034]=1; image[39035]=1; image[39036]=1; image[39037]=1; image[39038]=1; image[39039]=1; image[39040]=1; image[39041]=1; image[39042]=1; image[39043]=1; image[39044]=1; image[39045]=1; image[39046]=1; image[39047]=1; image[39048]=1; image[39049]=1; image[39050]=1; image[39051]=1; image[39052]=1; image[39053]=1; image[39054]=1; image[39055]=1; image[39056]=1; image[39057]=1; image[39058]=1; image[39059]=1; image[39060]=1; image[39061]=1; image[39062]=1; image[39063]=1; image[39064]=1; image[39065]=1; image[39066]=1; image[39067]=1; image[39068]=1; image[39069]=1; image[39070]=1; image[39071]=2; image[39072]=2; image[39073]=3; image[39074]=3; image[39075]=2; image[39076]=3; image[39077]=3; image[39078]=5; image[39079]=8; image[39080]=9; image[39081]=8; image[39082]=3; image[39083]=2; image[39084]=2; image[39085]=2; image[39086]=2; image[39087]=4; image[39088]=5; image[39089]=6; image[39090]=10; image[39091]=10; image[39092]=10; image[39093]=13; image[39094]=12; image[39095]=12; image[39096]=12; image[39097]=12; image[39098]=11; image[39099]=14; image[39100]=13; image[39101]=15; image[39102]=19; image[39103]=21; image[39104]=26; image[39105]=28; image[39106]=30; image[39107]=33; image[39108]=33; image[39109]=18; image[39110]=17; image[39111]=43; image[39112]=35; image[39113]=33; image[39114]=42; image[39115]=43; image[39116]=39; image[39117]=48; image[39118]=55; image[39119]=64; image[39120]=61; image[39121]=34; image[39122]=18; image[39123]=5; image[39124]=9; image[39125]=57; image[39126]=56; image[39127]=47; image[39128]=62; image[39129]=53; image[39130]=58; image[39131]=70; image[39132]=90; image[39133]=89; image[39134]=89; image[39135]=102; image[39136]=102; image[39137]=97; image[39138]=90; image[39139]=99; image[39140]=97; image[39141]=86; image[39142]=111; image[39143]=151; image[39144]=175; image[39145]=186; image[39146]=216; image[39147]=225; image[39148]=246; image[39149]=255; image[39150]=253; image[39151]=249; image[39152]=255; image[39153]=255; image[39154]=185; image[39155]=25; image[39156]=23; image[39157]=5; image[39158]=1; image[39159]=1; image[39160]=1; image[39161]=1; image[39162]=1; image[39163]=1; image[39164]=1; image[39165]=1; image[39166]=1; image[39167]=1; image[39168]=1; image[39169]=1; image[39170]=1; image[39171]=1; image[39172]=1; image[39173]=1; image[39174]=1; image[39175]=1; image[39176]=1; image[39177]=1; image[39178]=1; image[39179]=1; image[39180]=1; image[39181]=1; image[39182]=1; image[39183]=1; image[39184]=1; image[39185]=1; image[39186]=1; image[39187]=1; image[39188]=1; image[39189]=1; image[39190]=1; image[39191]=1; image[39192]=1; image[39193]=1; image[39194]=1; image[39195]=1; image[39196]=1; image[39197]=1; image[39198]=1; image[39199]=1; image[39200]=1; image[39201]=1; image[39202]=1; image[39203]=1; image[39204]=1; image[39205]=1; image[39206]=1; image[39207]=1; image[39208]=1; image[39209]=1; image[39210]=1; image[39211]=1; image[39212]=1; image[39213]=1; image[39214]=1; image[39215]=1; image[39216]=1; image[39217]=1; image[39218]=1; image[39219]=1; image[39220]=1; image[39221]=1; image[39222]=1; image[39223]=1; image[39224]=1; image[39225]=1; image[39226]=1; image[39227]=1; image[39228]=1; image[39229]=1; image[39230]=1; image[39231]=1; image[39232]=1; image[39233]=1; image[39234]=1; image[39235]=1; image[39236]=1; image[39237]=1; image[39238]=1; image[39239]=1; image[39240]=1; image[39241]=1; image[39242]=1; image[39243]=1; image[39244]=1; image[39245]=1; image[39246]=1; image[39247]=1; image[39248]=1; image[39249]=1; image[39250]=1; image[39251]=1; image[39252]=1; image[39253]=1; image[39254]=1; image[39255]=1; image[39256]=1; image[39257]=1; image[39258]=1; image[39259]=1; image[39260]=1; image[39261]=1; image[39262]=1; image[39263]=1; image[39264]=1; image[39265]=1; image[39266]=1; image[39267]=1; image[39268]=1; image[39269]=1; image[39270]=1; image[39271]=2; image[39272]=2; image[39273]=2; image[39274]=2; image[39275]=3; image[39276]=4; image[39277]=4; image[39278]=7; image[39279]=8; image[39280]=6; image[39281]=3; image[39282]=3; image[39283]=3; image[39284]=4; image[39285]=3; image[39286]=3; image[39287]=2; image[39288]=2; image[39289]=4; image[39290]=6; image[39291]=10; image[39292]=10; image[39293]=10; image[39294]=11; image[39295]=9; image[39296]=10; image[39297]=8; image[39298]=8; image[39299]=8; image[39300]=10; image[39301]=14; image[39302]=17; image[39303]=19; image[39304]=21; image[39305]=23; image[39306]=29; image[39307]=32; image[39308]=13; image[39309]=13; image[39310]=38; image[39311]=32; image[39312]=38; image[39313]=45; image[39314]=45; image[39315]=44; image[39316]=56; image[39317]=51; image[39318]=69; image[39319]=57; image[39320]=35; image[39321]=26; image[39322]=6; image[39323]=4; image[39324]=36; image[39325]=46; image[39326]=48; image[39327]=52; image[39328]=45; image[39329]=66; image[39330]=82; image[39331]=93; image[39332]=87; image[39333]=85; image[39334]=102; image[39335]=97; image[39336]=95; image[39337]=86; image[39338]=121; image[39339]=104; image[39340]=86; image[39341]=110; image[39342]=149; image[39343]=189; image[39344]=204; image[39345]=222; image[39346]=243; image[39347]=253; image[39348]=255; image[39349]=237; image[39350]=245; image[39351]=255; image[39352]=255; image[39353]=134; image[39354]=22; image[39355]=23; image[39356]=4; image[39357]=1; image[39358]=1; image[39359]=1; image[39360]=1; image[39361]=1; image[39362]=1; image[39363]=0; image[39364]=1; image[39365]=1; image[39366]=1; image[39367]=1; image[39368]=1; image[39369]=1; image[39370]=1; image[39371]=1; image[39372]=1; image[39373]=1; image[39374]=1; image[39375]=1; image[39376]=1; image[39377]=1; image[39378]=1; image[39379]=1; image[39380]=1; image[39381]=1; image[39382]=1; image[39383]=1; image[39384]=1; image[39385]=1; image[39386]=1; image[39387]=1; image[39388]=1; image[39389]=1; image[39390]=1; image[39391]=1; image[39392]=1; image[39393]=1; image[39394]=1; image[39395]=1; image[39396]=1; image[39397]=1; image[39398]=1; image[39399]=1; image[39400]=1; image[39401]=1; image[39402]=1; image[39403]=1; image[39404]=1; image[39405]=1; image[39406]=1; image[39407]=1; image[39408]=1; image[39409]=1; image[39410]=1; image[39411]=1; image[39412]=1; image[39413]=1; image[39414]=1; image[39415]=1; image[39416]=1; image[39417]=1; image[39418]=1; image[39419]=1; image[39420]=1; image[39421]=1; image[39422]=1; image[39423]=1; image[39424]=1; image[39425]=1; image[39426]=1; image[39427]=1; image[39428]=1; image[39429]=1; image[39430]=1; image[39431]=1; image[39432]=1; image[39433]=1; image[39434]=1; image[39435]=1; image[39436]=1; image[39437]=1; image[39438]=1; image[39439]=1; image[39440]=1; image[39441]=1; image[39442]=1; image[39443]=1; image[39444]=1; image[39445]=1; image[39446]=1; image[39447]=1; image[39448]=1; image[39449]=1; image[39450]=1; image[39451]=1; image[39452]=1; image[39453]=1; image[39454]=1; image[39455]=1; image[39456]=1; image[39457]=1; image[39458]=1; image[39459]=1; image[39460]=1; image[39461]=1; image[39462]=1; image[39463]=1; image[39464]=1; image[39465]=1; image[39466]=1; image[39467]=1; image[39468]=1; image[39469]=1; image[39470]=2; image[39471]=2; image[39472]=2; image[39473]=3; image[39474]=3; image[39475]=4; image[39476]=6; image[39477]=6; image[39478]=7; image[39479]=5; image[39480]=3; image[39481]=4; image[39482]=4; image[39483]=5; image[39484]=4; image[39485]=6; image[39486]=12; image[39487]=17; image[39488]=13; image[39489]=9; image[39490]=12; image[39491]=16; image[39492]=19; image[39493]=19; image[39494]=14; image[39495]=14; image[39496]=15; image[39497]=14; image[39498]=14; image[39499]=13; image[39500]=12; image[39501]=11; image[39502]=16; image[39503]=15; image[39504]=14; image[39505]=15; image[39506]=18; image[39507]=9; image[39508]=13; image[39509]=43; image[39510]=36; image[39511]=40; image[39512]=45; image[39513]=45; image[39514]=44; image[39515]=59; image[39516]=55; image[39517]=71; image[39518]=53; image[39519]=41; image[39520]=25; image[39521]=4; image[39522]=3; image[39523]=19; image[39524]=33; image[39525]=37; image[39526]=37; image[39527]=53; image[39528]=64; image[39529]=78; image[39530]=86; image[39531]=86; image[39532]=89; image[39533]=96; image[39534]=90; image[39535]=91; image[39536]=96; image[39537]=142; image[39538]=96; image[39539]=90; image[39540]=117; image[39541]=170; image[39542]=198; image[39543]=212; image[39544]=220; image[39545]=238; image[39546]=253; image[39547]=255; image[39548]=249; image[39549]=253; image[39550]=255; image[39551]=255; image[39552]=81; image[39553]=30; image[39554]=18; image[39555]=3; image[39556]=1; image[39557]=1; image[39558]=1; image[39559]=1; image[39560]=1; image[39561]=1; image[39562]=1; image[39563]=1; image[39564]=1; image[39565]=1; image[39566]=1; image[39567]=1; image[39568]=1; image[39569]=1; image[39570]=1; image[39571]=1; image[39572]=1; image[39573]=1; image[39574]=1; image[39575]=1; image[39576]=1; image[39577]=1; image[39578]=1; image[39579]=1; image[39580]=1; image[39581]=1; image[39582]=1; image[39583]=1; image[39584]=1; image[39585]=1; image[39586]=1; image[39587]=1; image[39588]=1; image[39589]=1; image[39590]=1; image[39591]=1; image[39592]=0; image[39593]=1; image[39594]=1; image[39595]=1; image[39596]=1; image[39597]=1; image[39598]=1; image[39599]=1; image[39600]=1; image[39601]=1; image[39602]=1; image[39603]=1; image[39604]=1; image[39605]=1; image[39606]=1; image[39607]=1; image[39608]=1; image[39609]=1; image[39610]=1; image[39611]=1; image[39612]=1; image[39613]=1; image[39614]=1; image[39615]=1; image[39616]=1; image[39617]=1; image[39618]=1; image[39619]=1; image[39620]=1; image[39621]=1; image[39622]=1; image[39623]=1; image[39624]=1; image[39625]=1; image[39626]=1; image[39627]=1; image[39628]=1; image[39629]=1; image[39630]=1; image[39631]=1; image[39632]=1; image[39633]=1; image[39634]=1; image[39635]=1; image[39636]=2; image[39637]=1; image[39638]=1; image[39639]=1; image[39640]=1; image[39641]=1; image[39642]=1; image[39643]=1; image[39644]=1; image[39645]=1; image[39646]=1; image[39647]=1; image[39648]=1; image[39649]=1; image[39650]=1; image[39651]=1; image[39652]=1; image[39653]=1; image[39654]=1; image[39655]=1; image[39656]=1; image[39657]=1; image[39658]=1; image[39659]=1; image[39660]=1; image[39661]=1; image[39662]=1; image[39663]=1; image[39664]=1; image[39665]=1; image[39666]=2; image[39667]=2; image[39668]=1; image[39669]=2; image[39670]=2; image[39671]=2; image[39672]=2; image[39673]=3; image[39674]=4; image[39675]=6; image[39676]=7; image[39677]=6; image[39678]=3; image[39679]=2; image[39680]=3; image[39681]=5; image[39682]=6; image[39683]=7; image[39684]=10; image[39685]=15; image[39686]=23; image[39687]=28; image[39688]=22; image[39689]=25; image[39690]=25; image[39691]=29; image[39692]=32; image[39693]=29; image[39694]=32; image[39695]=35; image[39696]=35; image[39697]=35; image[39698]=36; image[39699]=35; image[39700]=21; image[39701]=11; image[39702]=4; image[39703]=6; image[39704]=5; image[39705]=5; image[39706]=6; image[39707]=18; image[39708]=46; image[39709]=38; image[39710]=40; image[39711]=41; image[39712]=44; image[39713]=43; image[39714]=60; image[39715]=65; image[39716]=73; image[39717]=56; image[39718]=51; image[39719]=24; image[39720]=3; image[39721]=5; image[39722]=15; image[39723]=34; image[39724]=41; image[39725]=38; image[39726]=65; image[39727]=66; image[39728]=75; image[39729]=82; image[39730]=90; image[39731]=98; image[39732]=97; image[39733]=95; image[39734]=89; image[39735]=111; image[39736]=140; image[39737]=94; image[39738]=96; image[39739]=119; image[39740]=175; image[39741]=188; image[39742]=189; image[39743]=233; image[39744]=254; image[39745]=255; image[39746]=255; image[39747]=255; image[39748]=255; image[39749]=255; image[39750]=255; image[39751]=86; image[39752]=29; image[39753]=17; image[39754]=3; image[39755]=1; image[39756]=1; image[39757]=1; image[39758]=1; image[39759]=1; image[39760]=1; image[39761]=1; image[39762]=1; image[39763]=1; image[39764]=1; image[39765]=1; image[39766]=1; image[39767]=1; image[39768]=1; image[39769]=1; image[39770]=1; image[39771]=1; image[39772]=1; image[39773]=1; image[39774]=1; image[39775]=1; image[39776]=1; image[39777]=1; image[39778]=1; image[39779]=1; image[39780]=1; image[39781]=1; image[39782]=1; image[39783]=1; image[39784]=1; image[39785]=1; image[39786]=1; image[39787]=1; image[39788]=1; image[39789]=1; image[39790]=1; image[39791]=1; image[39792]=1; image[39793]=1; image[39794]=1; image[39795]=1; image[39796]=1; image[39797]=1; image[39798]=1; image[39799]=1; image[39800]=1; image[39801]=1; image[39802]=1; image[39803]=1; image[39804]=1; image[39805]=1; image[39806]=1; image[39807]=1; image[39808]=1; image[39809]=1; image[39810]=1; image[39811]=1; image[39812]=1; image[39813]=1; image[39814]=1; image[39815]=1; image[39816]=1; image[39817]=1; image[39818]=1; image[39819]=1; image[39820]=1; image[39821]=1; image[39822]=1; image[39823]=1; image[39824]=1; image[39825]=1; image[39826]=1; image[39827]=1; image[39828]=1; image[39829]=1; image[39830]=1; image[39831]=1; image[39832]=1; image[39833]=1; image[39834]=1; image[39835]=1; image[39836]=1; image[39837]=1; image[39838]=1; image[39839]=1; image[39840]=1; image[39841]=1; image[39842]=1; image[39843]=1; image[39844]=1; image[39845]=1; image[39846]=1; image[39847]=1; image[39848]=1; image[39849]=1; image[39850]=1; image[39851]=1; image[39852]=1; image[39853]=1; image[39854]=1; image[39855]=1; image[39856]=1; image[39857]=1; image[39858]=1; image[39859]=1; image[39860]=1; image[39861]=1; image[39862]=1; image[39863]=1; image[39864]=1; image[39865]=1; image[39866]=2; image[39867]=2; image[39868]=2; image[39869]=2; image[39870]=2; image[39871]=2; image[39872]=3; image[39873]=5; image[39874]=7; image[39875]=9; image[39876]=6; image[39877]=3; image[39878]=2; image[39879]=3; image[39880]=3; image[39881]=4; image[39882]=5; image[39883]=8; image[39884]=11; image[39885]=15; image[39886]=22; image[39887]=23; image[39888]=27; image[39889]=29; image[39890]=31; image[39891]=31; image[39892]=30; image[39893]=32; image[39894]=41; image[39895]=41; image[39896]=35; image[39897]=33; image[39898]=46; image[39899]=58; image[39900]=52; image[39901]=12; image[39902]=3; image[39903]=4; image[39904]=3; image[39905]=4; image[39906]=22; image[39907]=47; image[39908]=36; image[39909]=45; image[39910]=42; image[39911]=45; image[39912]=46; image[39913]=60; image[39914]=68; image[39915]=68; image[39916]=56; image[39917]=47; image[39918]=18; image[39919]=2; image[39920]=4; image[39921]=8; image[39922]=24; image[39923]=34; image[39924]=42; image[39925]=67; image[39926]=68; image[39927]=76; image[39928]=82; image[39929]=88; image[39930]=98; image[39931]=99; image[39932]=97; image[39933]=92; image[39934]=129; image[39935]=120; image[39936]=105; image[39937]=98; image[39938]=131; image[39939]=172; image[39940]=194; image[39941]=190; image[39942]=236; image[39943]=255; image[39944]=255; image[39945]=255; image[39946]=255; image[39947]=255; image[39948]=255; image[39949]=207; image[39950]=67; image[39951]=26; image[39952]=11; image[39953]=2; image[39954]=1; image[39955]=1; image[39956]=1; image[39957]=1; image[39958]=1; image[39959]=1; image[39960]=1; image[39961]=1; image[39962]=1; image[39963]=1; image[39964]=1; image[39965]=1; image[39966]=1; image[39967]=1; image[39968]=1; image[39969]=1; image[39970]=1; image[39971]=1; image[39972]=1; image[39973]=1; image[39974]=1; image[39975]=1; image[39976]=1; image[39977]=1; image[39978]=1; image[39979]=1; image[39980]=1; image[39981]=1; image[39982]=1; image[39983]=1; image[39984]=1; image[39985]=1; image[39986]=1; image[39987]=1; image[39988]=1; image[39989]=1; image[39990]=1; image[39991]=1; image[39992]=1; image[39993]=1; image[39994]=1; image[39995]=1; image[39996]=1; image[39997]=1; image[39998]=1; image[39999]=1; image[40000]=1; image[40001]=1; image[40002]=1; image[40003]=1; image[40004]=1; image[40005]=1; image[40006]=1; image[40007]=1; image[40008]=1; image[40009]=1; image[40010]=1; image[40011]=1; image[40012]=1; image[40013]=1; image[40014]=1; image[40015]=1; image[40016]=1; image[40017]=1; image[40018]=1; image[40019]=1; image[40020]=1; image[40021]=1; image[40022]=1; image[40023]=1; image[40024]=1; image[40025]=1; image[40026]=1; image[40027]=1; image[40028]=1; image[40029]=1; image[40030]=1; image[40031]=1; image[40032]=1; image[40033]=1; image[40034]=1; image[40035]=1; image[40036]=1; image[40037]=1; image[40038]=1; image[40039]=1; image[40040]=1; image[40041]=1; image[40042]=1; image[40043]=1; image[40044]=1; image[40045]=1; image[40046]=1; image[40047]=1; image[40048]=1; image[40049]=1; image[40050]=1; image[40051]=1; image[40052]=1; image[40053]=1; image[40054]=1; image[40055]=1; image[40056]=1; image[40057]=1; image[40058]=1; image[40059]=2; image[40060]=1; image[40061]=1; image[40062]=1; image[40063]=1; image[40064]=1; image[40065]=1; image[40066]=2; image[40067]=2; image[40068]=2; image[40069]=2; image[40070]=3; image[40071]=3; image[40072]=5; image[40073]=7; image[40074]=11; image[40075]=8; image[40076]=3; image[40077]=1; image[40078]=3; image[40079]=3; image[40080]=2; image[40081]=2; image[40082]=2; image[40083]=4; image[40084]=6; image[40085]=10; image[40086]=12; image[40087]=16; image[40088]=28; image[40089]=34; image[40090]=36; image[40091]=33; image[40092]=32; image[40093]=41; image[40094]=40; image[40095]=40; image[40096]=33; image[40097]=38; image[40098]=52; image[40099]=59; image[40100]=56; image[40101]=16; image[40102]=7; image[40103]=5; image[40104]=6; image[40105]=29; image[40106]=44; image[40107]=33; image[40108]=49; image[40109]=43; image[40110]=51; image[40111]=44; image[40112]=54; image[40113]=61; image[40114]=69; image[40115]=58; image[40116]=47; image[40117]=15; image[40118]=2; image[40119]=3; image[40120]=4; image[40121]=13; image[40122]=27; image[40123]=52; image[40124]=67; image[40125]=78; image[40126]=81; image[40127]=82; image[40128]=86; image[40129]=107; image[40130]=99; image[40131]=98; image[40132]=109; image[40133]=139; image[40134]=113; image[40135]=105; image[40136]=97; image[40137]=144; image[40138]=168; image[40139]=196; image[40140]=217; image[40141]=248; image[40142]=255; image[40143]=255; image[40144]=255; image[40145]=255; image[40146]=255; image[40147]=255; image[40148]=174; image[40149]=37; image[40150]=22; image[40151]=6; image[40152]=1; image[40153]=1; image[40154]=1; image[40155]=1; image[40156]=1; image[40157]=1; image[40158]=1; image[40159]=1; image[40160]=1; image[40161]=1; image[40162]=1; image[40163]=1; image[40164]=1; image[40165]=1; image[40166]=1; image[40167]=1; image[40168]=1; image[40169]=1; image[40170]=1; image[40171]=1; image[40172]=1; image[40173]=1; image[40174]=1; image[40175]=1; image[40176]=1; image[40177]=1; image[40178]=1; image[40179]=1; image[40180]=1; image[40181]=1; image[40182]=1; image[40183]=1; image[40184]=1; image[40185]=1; image[40186]=1; image[40187]=1; image[40188]=1; image[40189]=1; image[40190]=1; image[40191]=1; image[40192]=1; image[40193]=1; image[40194]=1; image[40195]=1; image[40196]=1; image[40197]=1; image[40198]=1; image[40199]=1; image[40200]=1; image[40201]=1; image[40202]=1; image[40203]=1; image[40204]=1; image[40205]=1; image[40206]=1; image[40207]=1; image[40208]=1; image[40209]=1; image[40210]=1; image[40211]=1; image[40212]=1; image[40213]=1; image[40214]=1; image[40215]=1; image[40216]=1; image[40217]=1; image[40218]=1; image[40219]=1; image[40220]=1; image[40221]=1; image[40222]=1; image[40223]=1; image[40224]=1; image[40225]=1; image[40226]=1; image[40227]=1; image[40228]=1; image[40229]=1; image[40230]=1; image[40231]=1; image[40232]=1; image[40233]=1; image[40234]=1; image[40235]=1; image[40236]=1; image[40237]=1; image[40238]=1; image[40239]=1; image[40240]=1; image[40241]=1; image[40242]=1; image[40243]=1; image[40244]=1; image[40245]=1; image[40246]=1; image[40247]=1; image[40248]=1; image[40249]=1; image[40250]=1; image[40251]=1; image[40252]=1; image[40253]=1; image[40254]=1; image[40255]=1; image[40256]=1; image[40257]=1; image[40258]=2; image[40259]=2; image[40260]=1; image[40261]=1; image[40262]=1; image[40263]=1; image[40264]=1; image[40265]=2; image[40266]=1; image[40267]=2; image[40268]=2; image[40269]=2; image[40270]=4; image[40271]=7; image[40272]=10; image[40273]=13; image[40274]=9; image[40275]=3; image[40276]=3; image[40277]=4; image[40278]=4; image[40279]=3; image[40280]=2; image[40281]=4; image[40282]=5; image[40283]=5; image[40284]=3; image[40285]=3; image[40286]=4; image[40287]=6; image[40288]=9; image[40289]=18; image[40290]=32; image[40291]=38; image[40292]=38; image[40293]=33; image[40294]=35; image[40295]=31; image[40296]=37; image[40297]=51; image[40298]=41; image[40299]=69; image[40300]=26; image[40301]=2; image[40302]=3; image[40303]=5; image[40304]=29; image[40305]=42; image[40306]=36; image[40307]=52; image[40308]=43; image[40309]=55; image[40310]=40; image[40311]=49; image[40312]=59; image[40313]=75; image[40314]=58; image[40315]=49; image[40316]=14; image[40317]=2; image[40318]=3; image[40319]=3; image[40320]=13; image[40321]=35; image[40322]=65; image[40323]=69; image[40324]=86; image[40325]=78; image[40326]=82; image[40327]=96; image[40328]=113; image[40329]=95; image[40330]=99; image[40331]=118; image[40332]=131; image[40333]=117; image[40334]=102; image[40335]=98; image[40336]=138; image[40337]=170; image[40338]=203; image[40339]=225; image[40340]=253; image[40341]=255; image[40342]=255; image[40343]=255; image[40344]=255; image[40345]=255; image[40346]=255; image[40347]=255; image[40348]=55; image[40349]=25; image[40350]=8; image[40351]=2; image[40352]=1; image[40353]=1; image[40354]=1; image[40355]=1; image[40356]=1; image[40357]=1; image[40358]=1; image[40359]=1; image[40360]=1; image[40361]=1; image[40362]=1; image[40363]=1; image[40364]=1; image[40365]=1; image[40366]=1; image[40367]=1; image[40368]=1; image[40369]=1; image[40370]=1; image[40371]=1; image[40372]=1; image[40373]=1; image[40374]=1; image[40375]=1; image[40376]=1; image[40377]=1; image[40378]=1; image[40379]=1; image[40380]=1; image[40381]=1; image[40382]=1; image[40383]=1; image[40384]=1; image[40385]=1; image[40386]=1; image[40387]=1; image[40388]=1; image[40389]=1; image[40390]=0; image[40391]=1; image[40392]=1; image[40393]=1; image[40394]=1; image[40395]=1; image[40396]=1; image[40397]=1; image[40398]=1; image[40399]=1; image[40400]=1; image[40401]=1; image[40402]=1; image[40403]=1; image[40404]=1; image[40405]=1; image[40406]=1; image[40407]=1; image[40408]=1; image[40409]=1; image[40410]=1; image[40411]=1; image[40412]=1; image[40413]=1; image[40414]=1; image[40415]=1; image[40416]=1; image[40417]=1; image[40418]=1; image[40419]=1; image[40420]=1; image[40421]=1; image[40422]=1; image[40423]=1; image[40424]=1; image[40425]=1; image[40426]=1; image[40427]=1; image[40428]=1; image[40429]=1; image[40430]=1; image[40431]=1; image[40432]=1; image[40433]=1; image[40434]=1; image[40435]=1; image[40436]=1; image[40437]=1; image[40438]=1; image[40439]=1; image[40440]=1; image[40441]=1; image[40442]=1; image[40443]=1; image[40444]=1; image[40445]=1; image[40446]=1; image[40447]=1; image[40448]=1; image[40449]=1; image[40450]=1; image[40451]=1; image[40452]=1; image[40453]=1; image[40454]=1; image[40455]=1; image[40456]=1; image[40457]=1; image[40458]=1; image[40459]=1; image[40460]=1; image[40461]=1; image[40462]=1; image[40463]=1; image[40464]=1; image[40465]=1; image[40466]=2; image[40467]=2; image[40468]=2; image[40469]=4; image[40470]=7; image[40471]=10; image[40472]=13; image[40473]=8; image[40474]=3; image[40475]=3; image[40476]=2; image[40477]=2; image[40478]=5; image[40479]=7; image[40480]=14; image[40481]=17; image[40482]=19; image[40483]=25; image[40484]=26; image[40485]=24; image[40486]=20; image[40487]=17; image[40488]=10; image[40489]=9; image[40490]=14; image[40491]=30; image[40492]=38; image[40493]=39; image[40494]=43; image[40495]=50; image[40496]=54; image[40497]=50; image[40498]=41; image[40499]=19; image[40500]=7; image[40501]=3; image[40502]=8; image[40503]=37; image[40504]=37; image[40505]=34; image[40506]=50; image[40507]=44; image[40508]=60; image[40509]=42; image[40510]=56; image[40511]=67; image[40512]=84; image[40513]=59; image[40514]=43; image[40515]=12; image[40516]=4; image[40517]=5; image[40518]=6; image[40519]=26; image[40520]=57; image[40521]=79; image[40522]=91; image[40523]=89; image[40524]=88; image[40525]=97; image[40526]=105; image[40527]=97; image[40528]=99; image[40529]=107; image[40530]=128; image[40531]=131; image[40532]=124; image[40533]=106; image[40534]=106; image[40535]=139; image[40536]=187; image[40537]=209; image[40538]=217; image[40539]=245; image[40540]=255; image[40541]=255; image[40542]=255; image[40543]=255; image[40544]=255; image[40545]=255; image[40546]=210; image[40547]=43; image[40548]=32; image[40549]=8; image[40550]=2; image[40551]=1; image[40552]=1; image[40553]=1; image[40554]=1; image[40555]=1; image[40556]=1; image[40557]=1; image[40558]=1; image[40559]=1; image[40560]=1; image[40561]=1; image[40562]=1; image[40563]=1; image[40564]=1; image[40565]=1; image[40566]=1; image[40567]=1; image[40568]=1; image[40569]=1; image[40570]=0; image[40571]=1; image[40572]=1; image[40573]=1; image[40574]=1; image[40575]=1; image[40576]=1; image[40577]=1; image[40578]=1; image[40579]=1; image[40580]=1; image[40581]=1; image[40582]=1; image[40583]=1; image[40584]=1; image[40585]=1; image[40586]=1; image[40587]=1; image[40588]=1; image[40589]=1; image[40590]=1; image[40591]=1; image[40592]=1; image[40593]=1; image[40594]=1; image[40595]=1; image[40596]=1; image[40597]=1; image[40598]=1; image[40599]=1; image[40600]=1; image[40601]=1; image[40602]=1; image[40603]=1; image[40604]=1; image[40605]=1; image[40606]=1; image[40607]=1; image[40608]=1; image[40609]=1; image[40610]=1; image[40611]=1; image[40612]=1; image[40613]=1; image[40614]=1; image[40615]=1; image[40616]=1; image[40617]=1; image[40618]=1; image[40619]=1; image[40620]=1; image[40621]=1; image[40622]=1; image[40623]=1; image[40624]=1; image[40625]=1; image[40626]=1; image[40627]=1; image[40628]=1; image[40629]=1; image[40630]=1; image[40631]=1; image[40632]=1; image[40633]=1; image[40634]=1; image[40635]=1; image[40636]=1; image[40637]=1; image[40638]=1; image[40639]=1; image[40640]=1; image[40641]=1; image[40642]=1; image[40643]=1; image[40644]=1; image[40645]=1; image[40646]=1; image[40647]=1; image[40648]=1; image[40649]=1; image[40650]=1; image[40651]=1; image[40652]=1; image[40653]=1; image[40654]=1; image[40655]=1; image[40656]=1; image[40657]=1; image[40658]=1; image[40659]=1; image[40660]=1; image[40661]=1; image[40662]=1; image[40663]=2; image[40664]=2; image[40665]=1; image[40666]=2; image[40667]=3; image[40668]=4; image[40669]=8; image[40670]=11; image[40671]=14; image[40672]=8; image[40673]=3; image[40674]=5; image[40675]=5; image[40676]=5; image[40677]=8; image[40678]=11; image[40679]=15; image[40680]=18; image[40681]=18; image[40682]=20; image[40683]=24; image[40684]=27; image[40685]=31; image[40686]=32; image[40687]=32; image[40688]=25; image[40689]=19; image[40690]=10; image[40691]=12; image[40692]=14; image[40693]=20; image[40694]=25; image[40695]=29; image[40696]=18; image[40697]=7; image[40698]=7; image[40699]=6; image[40700]=2; image[40701]=11; image[40702]=44; image[40703]=38; image[40704]=34; image[40705]=45; image[40706]=49; image[40707]=58; image[40708]=41; image[40709]=59; image[40710]=73; image[40711]=81; image[40712]=46; image[40713]=27; image[40714]=10; image[40715]=7; image[40716]=6; image[40717]=12; image[40718]=43; image[40719]=90; image[40720]=93; image[40721]=98; image[40722]=95; image[40723]=97; image[40724]=102; image[40725]=102; image[40726]=96; image[40727]=104; image[40728]=119; image[40729]=148; image[40730]=124; image[40731]=119; image[40732]=100; image[40733]=102; image[40734]=139; image[40735]=188; image[40736]=211; image[40737]=227; image[40738]=252; image[40739]=255; image[40740]=255; image[40741]=255; image[40742]=255; image[40743]=255; image[40744]=255; image[40745]=129; image[40746]=35; image[40747]=29; image[40748]=7; image[40749]=1; image[40750]=1; image[40751]=1; image[40752]=1; image[40753]=1; image[40754]=1; image[40755]=1; image[40756]=1; image[40757]=1; image[40758]=1; image[40759]=1; image[40760]=1; image[40761]=1; image[40762]=1; image[40763]=1; image[40764]=1; image[40765]=1; image[40766]=1; image[40767]=1; image[40768]=1; image[40769]=1; image[40770]=1; image[40771]=1; image[40772]=1; image[40773]=1; image[40774]=1; image[40775]=1; image[40776]=1; image[40777]=1; image[40778]=1; image[40779]=1; image[40780]=1; image[40781]=1; image[40782]=1; image[40783]=1; image[40784]=1; image[40785]=1; image[40786]=1; image[40787]=1; image[40788]=1; image[40789]=1; image[40790]=1; image[40791]=1; image[40792]=1; image[40793]=1; image[40794]=1; image[40795]=1; image[40796]=1; image[40797]=1; image[40798]=1; image[40799]=1; image[40800]=1; image[40801]=1; image[40802]=1; image[40803]=1; image[40804]=0; image[40805]=1; image[40806]=1; image[40807]=1; image[40808]=1; image[40809]=1; image[40810]=1; image[40811]=1; image[40812]=1; image[40813]=1; image[40814]=1; image[40815]=1; image[40816]=1; image[40817]=1; image[40818]=1; image[40819]=1; image[40820]=1; image[40821]=1; image[40822]=1; image[40823]=1; image[40824]=1; image[40825]=1; image[40826]=1; image[40827]=1; image[40828]=1; image[40829]=1; image[40830]=1; image[40831]=1; image[40832]=1; image[40833]=1; image[40834]=1; image[40835]=1; image[40836]=1; image[40837]=1; image[40838]=1; image[40839]=1; image[40840]=1; image[40841]=1; image[40842]=1; image[40843]=1; image[40844]=1; image[40845]=1; image[40846]=1; image[40847]=1; image[40848]=1; image[40849]=1; image[40850]=1; image[40851]=1; image[40852]=1; image[40853]=1; image[40854]=1; image[40855]=1; image[40856]=1; image[40857]=1; image[40858]=1; image[40859]=2; image[40860]=1; image[40861]=1; image[40862]=2; image[40863]=2; image[40864]=1; image[40865]=2; image[40866]=3; image[40867]=3; image[40868]=11; image[40869]=14; image[40870]=16; image[40871]=11; image[40872]=4; image[40873]=3; image[40874]=9; image[40875]=11; image[40876]=11; image[40877]=13; image[40878]=12; image[40879]=16; image[40880]=18; image[40881]=21; image[40882]=24; image[40883]=26; image[40884]=23; image[40885]=24; image[40886]=25; image[40887]=30; image[40888]=35; image[40889]=36; image[40890]=33; image[40891]=31; image[40892]=24; image[40893]=17; image[40894]=12; image[40895]=8; image[40896]=5; image[40897]=4; image[40898]=3; image[40899]=3; image[40900]=15; image[40901]=47; image[40902]=40; image[40903]=39; image[40904]=41; image[40905]=55; image[40906]=65; image[40907]=54; image[40908]=68; image[40909]=83; image[40910]=69; image[40911]=24; image[40912]=18; image[40913]=11; image[40914]=16; image[40915]=13; image[40916]=24; image[40917]=58; image[40918]=85; image[40919]=102; image[40920]=110; image[40921]=100; image[40922]=99; image[40923]=105; image[40924]=98; image[40925]=109; image[40926]=111; image[40927]=142; image[40928]=146; image[40929]=118; image[40930]=111; image[40931]=93; image[40932]=104; image[40933]=144; image[40934]=192; image[40935]=220; image[40936]=241; image[40937]=253; image[40938]=255; image[40939]=255; image[40940]=255; image[40941]=254; image[40942]=249; image[40943]=255; image[40944]=121; image[40945]=33; image[40946]=22; image[40947]=4; image[40948]=1; image[40949]=1; image[40950]=1; image[40951]=1; image[40952]=1; image[40953]=1; image[40954]=1; image[40955]=1; image[40956]=1; image[40957]=1; image[40958]=1; image[40959]=1; image[40960]=1; image[40961]=1; image[40962]=1; image[40963]=1; image[40964]=1; image[40965]=1; image[40966]=1; image[40967]=1; image[40968]=1; image[40969]=1; image[40970]=1; image[40971]=1; image[40972]=1; image[40973]=1; image[40974]=1; image[40975]=1; image[40976]=1; image[40977]=1; image[40978]=0; image[40979]=1; image[40980]=1; image[40981]=1; image[40982]=1; image[40983]=1; image[40984]=1; image[40985]=1; image[40986]=1; image[40987]=1; image[40988]=1; image[40989]=1; image[40990]=1; image[40991]=1; image[40992]=1; image[40993]=1; image[40994]=1; image[40995]=1; image[40996]=1; image[40997]=1; image[40998]=1; image[40999]=1; image[41000]=1; image[41001]=1; image[41002]=1; image[41003]=1; image[41004]=1; image[41005]=1; image[41006]=1; image[41007]=1; image[41008]=1; image[41009]=1; image[41010]=1; image[41011]=1; image[41012]=1; image[41013]=1; image[41014]=1; image[41015]=1; image[41016]=1; image[41017]=1; image[41018]=1; image[41019]=1; image[41020]=1; image[41021]=1; image[41022]=1; image[41023]=1; image[41024]=1; image[41025]=1; image[41026]=1; image[41027]=1; image[41028]=1; image[41029]=1; image[41030]=1; image[41031]=1; image[41032]=1; image[41033]=1; image[41034]=1; image[41035]=1; image[41036]=1; image[41037]=1; image[41038]=1; image[41039]=1; image[41040]=1; image[41041]=1; image[41042]=1; image[41043]=1; image[41044]=1; image[41045]=1; image[41046]=1; image[41047]=1; image[41048]=1; image[41049]=1; image[41050]=1; image[41051]=1; image[41052]=1; image[41053]=1; image[41054]=1; image[41055]=1; image[41056]=1; image[41057]=2; image[41058]=1; image[41059]=1; image[41060]=1; image[41061]=2; image[41062]=1; image[41063]=2; image[41064]=2; image[41065]=3; image[41066]=4; image[41067]=11; image[41068]=14; image[41069]=17; image[41070]=15; image[41071]=7; image[41072]=2; image[41073]=8; image[41074]=11; image[41075]=14; image[41076]=14; image[41077]=15; image[41078]=15; image[41079]=17; image[41080]=21; image[41081]=23; image[41082]=23; image[41083]=23; image[41084]=27; image[41085]=26; image[41086]=28; image[41087]=26; image[41088]=27; image[41089]=34; image[41090]=40; image[41091]=53; image[41092]=54; image[41093]=55; image[41094]=62; image[41095]=42; image[41096]=24; image[41097]=14; image[41098]=6; image[41099]=18; image[41100]=44; image[41101]=36; image[41102]=41; image[41103]=38; image[41104]=50; image[41105]=63; image[41106]=65; image[41107]=65; image[41108]=82; image[41109]=56; image[41110]=13; image[41111]=14; image[41112]=11; image[41113]=24; image[41114]=35; image[41115]=40; image[41116]=62; image[41117]=87; image[41118]=111; image[41119]=99; image[41120]=100; image[41121]=104; image[41122]=104; image[41123]=94; image[41124]=106; image[41125]=111; image[41126]=148; image[41127]=124; image[41128]=117; image[41129]=115; image[41130]=107; image[41131]=112; image[41132]=148; image[41133]=208; image[41134]=223; image[41135]=242; image[41136]=255; image[41137]=255; image[41138]=255; image[41139]=255; image[41140]=255; image[41141]=254; image[41142]=255; image[41143]=96; image[41144]=36; image[41145]=25; image[41146]=3; image[41147]=1; image[41148]=1; image[41149]=1; image[41150]=1; image[41151]=1; image[41152]=1; image[41153]=1; image[41154]=1; image[41155]=1; image[41156]=1; image[41157]=1; image[41158]=1; image[41159]=1; image[41160]=1; image[41161]=1; image[41162]=1; image[41163]=1; image[41164]=1; image[41165]=1; image[41166]=1; image[41167]=1; image[41168]=1; image[41169]=1; image[41170]=1; image[41171]=1; image[41172]=1; image[41173]=1; image[41174]=1; image[41175]=1; image[41176]=1; image[41177]=1; image[41178]=1; image[41179]=1; image[41180]=1; image[41181]=1; image[41182]=1; image[41183]=1; image[41184]=1; image[41185]=1; image[41186]=1; image[41187]=1; image[41188]=1; image[41189]=1; image[41190]=1; image[41191]=1; image[41192]=1; image[41193]=1; image[41194]=1; image[41195]=1; image[41196]=1; image[41197]=1; image[41198]=1; image[41199]=1; image[41200]=1; image[41201]=1; image[41202]=1; image[41203]=1; image[41204]=1; image[41205]=1; image[41206]=1; image[41207]=1; image[41208]=1; image[41209]=1; image[41210]=1; image[41211]=1; image[41212]=1; image[41213]=1; image[41214]=1; image[41215]=1; image[41216]=1; image[41217]=1; image[41218]=1; image[41219]=1; image[41220]=1; image[41221]=1; image[41222]=1; image[41223]=1; image[41224]=1; image[41225]=1; image[41226]=1; image[41227]=1; image[41228]=1; image[41229]=1; image[41230]=1; image[41231]=1; image[41232]=1; image[41233]=1; image[41234]=1; image[41235]=1; image[41236]=1; image[41237]=1; image[41238]=1; image[41239]=1; image[41240]=1; image[41241]=1; image[41242]=1; image[41243]=1; image[41244]=1; image[41245]=1; image[41246]=1; image[41247]=1; image[41248]=1; image[41249]=1; image[41250]=1; image[41251]=1; image[41252]=1; image[41253]=1; image[41254]=2; image[41255]=1; image[41256]=1; image[41257]=1; image[41258]=2; image[41259]=2; image[41260]=2; image[41261]=2; image[41262]=2; image[41263]=2; image[41264]=3; image[41265]=5; image[41266]=8; image[41267]=12; image[41268]=17; image[41269]=14; image[41270]=7; image[41271]=2; image[41272]=7; image[41273]=10; image[41274]=15; image[41275]=16; image[41276]=18; image[41277]=19; image[41278]=17; image[41279]=20; image[41280]=22; image[41281]=21; image[41282]=21; image[41283]=24; image[41284]=24; image[41285]=31; image[41286]=35; image[41287]=34; image[41288]=30; image[41289]=30; image[41290]=34; image[41291]=33; image[41292]=32; image[41293]=54; image[41294]=66; image[41295]=59; image[41296]=37; image[41297]=8; image[41298]=24; image[41299]=47; image[41300]=34; image[41301]=42; image[41302]=39; image[41303]=57; image[41304]=61; image[41305]=71; image[41306]=68; image[41307]=86; image[41308]=46; image[41309]=8; image[41310]=11; image[41311]=12; image[41312]=15; image[41313]=47; image[41314]=51; image[41315]=58; image[41316]=125; image[41317]=118; image[41318]=81; image[41319]=96; image[41320]=103; image[41321]=97; image[41322]=98; image[41323]=113; image[41324]=135; image[41325]=141; image[41326]=115; image[41327]=121; image[41328]=111; image[41329]=103; image[41330]=113; image[41331]=166; image[41332]=221; image[41333]=245; image[41334]=254; image[41335]=255; image[41336]=255; image[41337]=255; image[41338]=255; image[41339]=255; image[41340]=255; image[41341]=241; image[41342]=63; image[41343]=33; image[41344]=17; image[41345]=2; image[41346]=1; image[41347]=1; image[41348]=1; image[41349]=1; image[41350]=1; image[41351]=1; image[41352]=1; image[41353]=1; image[41354]=1; image[41355]=1; image[41356]=1; image[41357]=1; image[41358]=1; image[41359]=1; image[41360]=1; image[41361]=1; image[41362]=1; image[41363]=1; image[41364]=1; image[41365]=1; image[41366]=1; image[41367]=1; image[41368]=1; image[41369]=1; image[41370]=1; image[41371]=1; image[41372]=1; image[41373]=1; image[41374]=1; image[41375]=1; image[41376]=1; image[41377]=1; image[41378]=1; image[41379]=1; image[41380]=1; image[41381]=1; image[41382]=1; image[41383]=1; image[41384]=1; image[41385]=1; image[41386]=1; image[41387]=1; image[41388]=0; image[41389]=1; image[41390]=1; image[41391]=1; image[41392]=1; image[41393]=1; image[41394]=1; image[41395]=1; image[41396]=1; image[41397]=1; image[41398]=1; image[41399]=1; image[41400]=1; image[41401]=1; image[41402]=1; image[41403]=1; image[41404]=1; image[41405]=1; image[41406]=1; image[41407]=1; image[41408]=1; image[41409]=1; image[41410]=1; image[41411]=1; image[41412]=1; image[41413]=1; image[41414]=1; image[41415]=1; image[41416]=1; image[41417]=1; image[41418]=1; image[41419]=1; image[41420]=1; image[41421]=1; image[41422]=1; image[41423]=1; image[41424]=1; image[41425]=1; image[41426]=1; image[41427]=1; image[41428]=1; image[41429]=1; image[41430]=1; image[41431]=1; image[41432]=1; image[41433]=1; image[41434]=1; image[41435]=1; image[41436]=1; image[41437]=1; image[41438]=1; image[41439]=1; image[41440]=1; image[41441]=1; image[41442]=1; image[41443]=1; image[41444]=1; image[41445]=1; image[41446]=1; image[41447]=1; image[41448]=1; image[41449]=1; image[41450]=1; image[41451]=1; image[41452]=1; image[41453]=1; image[41454]=1; image[41455]=1; image[41456]=2; image[41457]=1; image[41458]=1; image[41459]=2; image[41460]=2; image[41461]=2; image[41462]=2; image[41463]=3; image[41464]=5; image[41465]=12; image[41466]=12; image[41467]=10; image[41468]=5; image[41469]=4; image[41470]=3; image[41471]=7; image[41472]=10; image[41473]=12; image[41474]=14; image[41475]=17; image[41476]=18; image[41477]=19; image[41478]=21; image[41479]=21; image[41480]=21; image[41481]=21; image[41482]=24; image[41483]=27; image[41484]=27; image[41485]=31; image[41486]=32; image[41487]=31; image[41488]=35; image[41489]=36; image[41490]=38; image[41491]=42; image[41492]=45; image[41493]=55; image[41494]=49; image[41495]=30; image[41496]=10; image[41497]=36; image[41498]=46; image[41499]=35; image[41500]=39; image[41501]=38; image[41502]=62; image[41503]=66; image[41504]=74; image[41505]=70; image[41506]=78; image[41507]=30; image[41508]=5; image[41509]=8; image[41510]=11; image[41511]=28; image[41512]=74; image[41513]=62; image[41514]=81; image[41515]=112; image[41516]=96; image[41517]=91; image[41518]=89; image[41519]=101; image[41520]=97; image[41521]=108; image[41522]=119; image[41523]=139; image[41524]=121; image[41525]=109; image[41526]=119; image[41527]=108; image[41528]=98; image[41529]=114; image[41530]=177; image[41531]=217; image[41532]=253; image[41533]=247; image[41534]=255; image[41535]=255; image[41536]=255; image[41537]=255; image[41538]=255; image[41539]=255; image[41540]=208; image[41541]=48; image[41542]=33; image[41543]=8; image[41544]=2; image[41545]=1; image[41546]=1; image[41547]=1; image[41548]=1; image[41549]=1; image[41550]=1; image[41551]=1; image[41552]=1; image[41553]=1; image[41554]=1; image[41555]=1; image[41556]=1; image[41557]=1; image[41558]=1; image[41559]=1; image[41560]=1; image[41561]=1; image[41562]=1; image[41563]=1; image[41564]=1; image[41565]=1; image[41566]=1; image[41567]=1; image[41568]=1; image[41569]=1; image[41570]=1; image[41571]=1; image[41572]=1; image[41573]=1; image[41574]=1; image[41575]=1; image[41576]=1; image[41577]=1; image[41578]=1; image[41579]=1; image[41580]=1; image[41581]=1; image[41582]=1; image[41583]=1; image[41584]=1; image[41585]=1; image[41586]=1; image[41587]=1; image[41588]=1; image[41589]=1; image[41590]=1; image[41591]=1; image[41592]=1; image[41593]=1; image[41594]=1; image[41595]=1; image[41596]=1; image[41597]=1; image[41598]=1; image[41599]=1; image[41600]=1; image[41601]=1; image[41602]=1; image[41603]=1; image[41604]=1; image[41605]=1; image[41606]=1; image[41607]=1; image[41608]=1; image[41609]=1; image[41610]=1; image[41611]=1; image[41612]=1; image[41613]=1; image[41614]=1; image[41615]=1; image[41616]=1; image[41617]=1; image[41618]=1; image[41619]=1; image[41620]=1; image[41621]=1; image[41622]=1; image[41623]=1; image[41624]=1; image[41625]=1; image[41626]=1; image[41627]=1; image[41628]=1; image[41629]=1; image[41630]=1; image[41631]=1; image[41632]=1; image[41633]=1; image[41634]=1; image[41635]=1; image[41636]=1; image[41637]=1; image[41638]=1; image[41639]=1; image[41640]=1; image[41641]=1; image[41642]=1; image[41643]=1; image[41644]=1; image[41645]=1; image[41646]=1; image[41647]=1; image[41648]=1; image[41649]=1; image[41650]=1; image[41651]=1; image[41652]=1; image[41653]=2; image[41654]=1; image[41655]=1; image[41656]=1; image[41657]=1; image[41658]=2; image[41659]=2; image[41660]=2; image[41661]=2; image[41662]=3; image[41663]=7; image[41664]=15; image[41665]=13; image[41666]=8; image[41667]=7; image[41668]=3; image[41669]=3; image[41670]=7; image[41671]=11; image[41672]=13; image[41673]=13; image[41674]=15; image[41675]=15; image[41676]=19; image[41677]=18; image[41678]=18; image[41679]=19; image[41680]=24; image[41681]=25; image[41682]=26; image[41683]=27; image[41684]=28; image[41685]=29; image[41686]=31; image[41687]=36; image[41688]=38; image[41689]=36; image[41690]=40; image[41691]=44; image[41692]=46; image[41693]=40; image[41694]=20; image[41695]=15; image[41696]=45; image[41697]=41; image[41698]=38; image[41699]=43; image[41700]=44; image[41701]=68; image[41702]=68; image[41703]=77; image[41704]=87; image[41705]=84; image[41706]=29; image[41707]=6; image[41708]=7; image[41709]=13; image[41710]=48; image[41711]=98; image[41712]=82; image[41713]=95; image[41714]=78; image[41715]=87; image[41716]=90; image[41717]=91; image[41718]=98; image[41719]=104; image[41720]=120; image[41721]=126; image[41722]=127; image[41723]=110; image[41724]=95; image[41725]=102; image[41726]=101; image[41727]=97; image[41728]=118; image[41729]=180; image[41730]=214; image[41731]=247; image[41732]=253; image[41733]=255; image[41734]=255; image[41735]=255; image[41736]=255; image[41737]=255; image[41738]=255; image[41739]=182; image[41740]=42; image[41741]=37; image[41742]=7; image[41743]=1; image[41744]=1; image[41745]=1; image[41746]=1; image[41747]=1; image[41748]=1; image[41749]=1; image[41750]=1; image[41751]=1; image[41752]=1; image[41753]=1; image[41754]=1; image[41755]=1; image[41756]=1; image[41757]=1; image[41758]=1; image[41759]=1; image[41760]=1; image[41761]=1; image[41762]=1; image[41763]=1; image[41764]=1; image[41765]=1; image[41766]=1; image[41767]=0; image[41768]=1; image[41769]=1; image[41770]=1; image[41771]=1; image[41772]=1; image[41773]=1; image[41774]=1; image[41775]=1; image[41776]=1; image[41777]=1; image[41778]=1; image[41779]=1; image[41780]=1; image[41781]=1; image[41782]=1; image[41783]=1; image[41784]=1; image[41785]=1; image[41786]=1; image[41787]=1; image[41788]=1; image[41789]=1; image[41790]=1; image[41791]=1; image[41792]=1; image[41793]=1; image[41794]=1; image[41795]=1; image[41796]=1; image[41797]=1; image[41798]=1; image[41799]=1; image[41800]=1; image[41801]=1; image[41802]=1; image[41803]=1; image[41804]=1; image[41805]=1; image[41806]=1; image[41807]=1; image[41808]=1; image[41809]=1; image[41810]=1; image[41811]=1; image[41812]=1; image[41813]=1; image[41814]=1; image[41815]=1; image[41816]=1; image[41817]=1; image[41818]=1; image[41819]=1; image[41820]=1; image[41821]=1; image[41822]=1; image[41823]=1; image[41824]=1; image[41825]=1; image[41826]=1; image[41827]=1; image[41828]=1; image[41829]=1; image[41830]=1; image[41831]=1; image[41832]=1; image[41833]=1; image[41834]=1; image[41835]=1; image[41836]=1; image[41837]=1; image[41838]=1; image[41839]=1; image[41840]=1; image[41841]=1; image[41842]=1; image[41843]=1; image[41844]=1; image[41845]=1; image[41846]=1; image[41847]=1; image[41848]=1; image[41849]=1; image[41850]=2; image[41851]=2; image[41852]=2; image[41853]=1; image[41854]=1; image[41855]=1; image[41856]=1; image[41857]=1; image[41858]=2; image[41859]=2; image[41860]=2; image[41861]=5; image[41862]=7; image[41863]=12; image[41864]=11; image[41865]=7; image[41866]=9; image[41867]=3; image[41868]=4; image[41869]=8; image[41870]=12; image[41871]=14; image[41872]=16; image[41873]=18; image[41874]=14; image[41875]=16; image[41876]=15; image[41877]=16; image[41878]=17; image[41879]=24; image[41880]=28; image[41881]=28; image[41882]=31; image[41883]=28; image[41884]=31; image[41885]=34; image[41886]=35; image[41887]=41; image[41888]=40; image[41889]=37; image[41890]=38; image[41891]=43; image[41892]=45; image[41893]=16; image[41894]=22; image[41895]=49; image[41896]=35; image[41897]=35; image[41898]=43; image[41899]=47; image[41900]=72; image[41901]=69; image[41902]=77; image[41903]=96; image[41904]=82; image[41905]=28; image[41906]=8; image[41907]=5; image[41908]=14; image[41909]=43; image[41910]=91; image[41911]=94; image[41912]=78; image[41913]=73; image[41914]=83; image[41915]=85; image[41916]=94; image[41917]=91; image[41918]=152; image[41919]=177; image[41920]=126; image[41921]=113; image[41922]=93; image[41923]=76; image[41924]=85; image[41925]=95; image[41926]=93; image[41927]=117; image[41928]=171; image[41929]=214; image[41930]=246; image[41931]=255; image[41932]=255; image[41933]=255; image[41934]=255; image[41935]=255; image[41936]=255; image[41937]=255; image[41938]=154; image[41939]=42; image[41940]=29; image[41941]=6; image[41942]=1; image[41943]=1; image[41944]=1; image[41945]=1; image[41946]=1; image[41947]=1; image[41948]=1; image[41949]=1; image[41950]=1; image[41951]=1; image[41952]=1; image[41953]=1; image[41954]=1; image[41955]=1; image[41956]=1; image[41957]=1; image[41958]=1; image[41959]=1; image[41960]=1; image[41961]=1; image[41962]=1; image[41963]=1; image[41964]=1; image[41965]=1; image[41966]=1; image[41967]=1; image[41968]=1; image[41969]=1; image[41970]=1; image[41971]=1; image[41972]=1; image[41973]=1; image[41974]=1; image[41975]=1; image[41976]=1; image[41977]=1; image[41978]=1; image[41979]=1; image[41980]=1; image[41981]=1; image[41982]=1; image[41983]=1; image[41984]=1; image[41985]=1; image[41986]=1; image[41987]=1; image[41988]=1; image[41989]=1; image[41990]=1; image[41991]=1; image[41992]=1; image[41993]=1; image[41994]=1; image[41995]=1; image[41996]=1; image[41997]=1; image[41998]=1; image[41999]=1; image[42000]=1; image[42001]=1; image[42002]=1; image[42003]=1; image[42004]=1; image[42005]=1; image[42006]=1; image[42007]=1; image[42008]=1; image[42009]=1; image[42010]=1; image[42011]=1; image[42012]=1; image[42013]=1; image[42014]=1; image[42015]=1; image[42016]=1; image[42017]=1; image[42018]=1; image[42019]=1; image[42020]=1; image[42021]=1; image[42022]=1; image[42023]=1; image[42024]=1; image[42025]=1; image[42026]=1; image[42027]=1; image[42028]=1; image[42029]=1; image[42030]=1; image[42031]=1; image[42032]=1; image[42033]=1; image[42034]=1; image[42035]=1; image[42036]=1; image[42037]=1; image[42038]=1; image[42039]=1; image[42040]=1; image[42041]=1; image[42042]=1; image[42043]=1; image[42044]=1; image[42045]=1; image[42046]=1; image[42047]=1; image[42048]=1; image[42049]=1; image[42050]=1; image[42051]=1; image[42052]=1; image[42053]=1; image[42054]=1; image[42055]=1; image[42056]=1; image[42057]=1; image[42058]=2; image[42059]=2; image[42060]=5; image[42061]=7; image[42062]=7; image[42063]=6; image[42064]=3; image[42065]=5; image[42066]=3; image[42067]=5; image[42068]=10; image[42069]=13; image[42070]=14; image[42071]=16; image[42072]=15; image[42073]=18; image[42074]=20; image[42075]=18; image[42076]=21; image[42077]=20; image[42078]=24; image[42079]=28; image[42080]=29; image[42081]=29; image[42082]=27; image[42083]=27; image[42084]=32; image[42085]=38; image[42086]=39; image[42087]=39; image[42088]=38; image[42089]=40; image[42090]=48; image[42091]=39; image[42092]=17; image[42093]=33; image[42094]=47; image[42095]=36; image[42096]=40; image[42097]=40; image[42098]=54; image[42099]=72; image[42100]=65; image[42101]=75; image[42102]=84; image[42103]=69; image[42104]=20; image[42105]=6; image[42106]=5; image[42107]=18; image[42108]=62; image[42109]=123; image[42110]=101; image[42111]=65; image[42112]=74; image[42113]=78; image[42114]=91; image[42115]=96; image[42116]=95; image[42117]=138; image[42118]=145; image[42119]=121; image[42120]=104; image[42121]=87; image[42122]=73; image[42123]=82; image[42124]=90; image[42125]=90; image[42126]=125; image[42127]=185; image[42128]=208; image[42129]=246; image[42130]=255; image[42131]=255; image[42132]=255; image[42133]=255; image[42134]=255; image[42135]=255; image[42136]=255; image[42137]=120; image[42138]=36; image[42139]=20; image[42140]=5; image[42141]=1; image[42142]=1; image[42143]=1; image[42144]=1; image[42145]=1; image[42146]=1; image[42147]=1; image[42148]=1; image[42149]=1; image[42150]=1; image[42151]=1; image[42152]=1; image[42153]=1; image[42154]=1; image[42155]=1; image[42156]=1; image[42157]=1; image[42158]=1; image[42159]=1; image[42160]=1; image[42161]=1; image[42162]=1; image[42163]=1; image[42164]=1; image[42165]=1; image[42166]=1; image[42167]=1; image[42168]=1; image[42169]=1; image[42170]=1; image[42171]=1; image[42172]=1; image[42173]=1; image[42174]=1; image[42175]=1; image[42176]=1; image[42177]=1; image[42178]=1; image[42179]=1; image[42180]=1; image[42181]=1; image[42182]=1; image[42183]=1; image[42184]=1; image[42185]=1; image[42186]=1; image[42187]=1; image[42188]=1; image[42189]=1; image[42190]=1; image[42191]=1; image[42192]=1; image[42193]=1; image[42194]=1; image[42195]=1; image[42196]=1; image[42197]=1; image[42198]=1; image[42199]=1; image[42200]=1; image[42201]=1; image[42202]=1; image[42203]=1; image[42204]=1; image[42205]=1; image[42206]=1; image[42207]=1; image[42208]=1; image[42209]=1; image[42210]=1; image[42211]=1; image[42212]=1; image[42213]=1; image[42214]=1; image[42215]=1; image[42216]=1; image[42217]=1; image[42218]=1; image[42219]=1; image[42220]=1; image[42221]=1; image[42222]=1; image[42223]=1; image[42224]=1; image[42225]=1; image[42226]=1; image[42227]=1; image[42228]=1; image[42229]=1; image[42230]=1; image[42231]=1; image[42232]=1; image[42233]=1; image[42234]=1; image[42235]=1; image[42236]=1; image[42237]=1; image[42238]=1; image[42239]=1; image[42240]=1; image[42241]=1; image[42242]=1; image[42243]=1; image[42244]=1; image[42245]=1; image[42246]=1; image[42247]=1; image[42248]=1; image[42249]=1; image[42250]=2; image[42251]=2; image[42252]=1; image[42253]=1; image[42254]=1; image[42255]=2; image[42256]=2; image[42257]=2; image[42258]=2; image[42259]=4; image[42260]=6; image[42261]=4; image[42262]=3; image[42263]=2; image[42264]=3; image[42265]=2; image[42266]=7; image[42267]=11; image[42268]=13; image[42269]=15; image[42270]=18; image[42271]=17; image[42272]=21; image[42273]=21; image[42274]=20; image[42275]=21; image[42276]=19; image[42277]=25; image[42278]=27; image[42279]=27; image[42280]=24; image[42281]=23; image[42282]=26; image[42283]=28; image[42284]=34; image[42285]=40; image[42286]=42; image[42287]=43; image[42288]=46; image[42289]=61; image[42290]=30; image[42291]=14; image[42292]=45; image[42293]=47; image[42294]=37; image[42295]=44; image[42296]=42; image[42297]=54; image[42298]=68; image[42299]=62; image[42300]=70; image[42301]=78; image[42302]=74; image[42303]=26; image[42304]=7; image[42305]=8; image[42306]=36; image[42307]=122; image[42308]=154; image[42309]=102; image[42310]=73; image[42311]=74; image[42312]=82; image[42313]=96; image[42314]=99; image[42315]=112; image[42316]=123; image[42317]=123; image[42318]=135; image[42319]=91; image[42320]=77; image[42321]=74; image[42322]=75; image[42323]=80; image[42324]=84; image[42325]=134; image[42326]=205; image[42327]=214; image[42328]=247; image[42329]=255; image[42330]=255; image[42331]=255; image[42332]=255; image[42333]=255; image[42334]=255; image[42335]=244; image[42336]=96; image[42337]=37; image[42338]=17; image[42339]=3; image[42340]=1; image[42341]=1; image[42342]=1; image[42343]=1; image[42344]=1; image[42345]=1; image[42346]=1; image[42347]=1; image[42348]=1; image[42349]=1; image[42350]=1; image[42351]=1; image[42352]=1; image[42353]=1; image[42354]=1; image[42355]=1; image[42356]=1; image[42357]=1; image[42358]=1; image[42359]=1; image[42360]=1; image[42361]=1; image[42362]=1; image[42363]=1; image[42364]=1; image[42365]=1; image[42366]=1; image[42367]=1; image[42368]=1; image[42369]=1; image[42370]=1; image[42371]=1; image[42372]=1; image[42373]=1; image[42374]=1; image[42375]=1; image[42376]=1; image[42377]=1; image[42378]=1; image[42379]=1; image[42380]=1; image[42381]=1; image[42382]=1; image[42383]=1; image[42384]=1; image[42385]=1; image[42386]=1; image[42387]=1; image[42388]=1; image[42389]=1; image[42390]=1; image[42391]=1; image[42392]=1; image[42393]=1; image[42394]=1; image[42395]=1; image[42396]=1; image[42397]=1; image[42398]=1; image[42399]=1; image[42400]=1; image[42401]=1; image[42402]=1; image[42403]=1; image[42404]=1; image[42405]=1; image[42406]=1; image[42407]=1; image[42408]=1; image[42409]=1; image[42410]=1; image[42411]=1; image[42412]=1; image[42413]=1; image[42414]=1; image[42415]=1; image[42416]=1; image[42417]=1; image[42418]=1; image[42419]=1; image[42420]=1; image[42421]=1; image[42422]=1; image[42423]=1; image[42424]=1; image[42425]=1; image[42426]=1; image[42427]=1; image[42428]=1; image[42429]=1; image[42430]=1; image[42431]=1; image[42432]=1; image[42433]=1; image[42434]=1; image[42435]=1; image[42436]=1; image[42437]=1; image[42438]=1; image[42439]=1; image[42440]=1; image[42441]=1; image[42442]=1; image[42443]=1; image[42444]=1; image[42445]=1; image[42446]=1; image[42447]=1; image[42448]=2; image[42449]=1; image[42450]=1; image[42451]=1; image[42452]=1; image[42453]=1; image[42454]=2; image[42455]=2; image[42456]=2; image[42457]=3; image[42458]=4; image[42459]=3; image[42460]=6; image[42461]=5; image[42462]=2; image[42463]=2; image[42464]=3; image[42465]=8; image[42466]=11; image[42467]=14; image[42468]=15; image[42469]=17; image[42470]=18; image[42471]=20; image[42472]=20; image[42473]=22; image[42474]=23; image[42475]=22; image[42476]=29; image[42477]=28; image[42478]=23; image[42479]=21; image[42480]=21; image[42481]=25; image[42482]=27; image[42483]=29; image[42484]=42; image[42485]=44; image[42486]=37; image[42487]=39; image[42488]=54; image[42489]=26; image[42490]=24; image[42491]=58; image[42492]=44; image[42493]=36; image[42494]=39; image[42495]=40; image[42496]=56; image[42497]=71; image[42498]=63; image[42499]=62; image[42500]=72; image[42501]=72; image[42502]=29; image[42503]=8; image[42504]=8; image[42505]=48; image[42506]=131; image[42507]=168; image[42508]=104; image[42509]=76; image[42510]=79; image[42511]=94; image[42512]=107; image[42513]=102; image[42514]=112; image[42515]=115; image[42516]=115; image[42517]=132; image[42518]=95; image[42519]=67; image[42520]=74; image[42521]=71; image[42522]=77; image[42523]=81; image[42524]=148; image[42525]=215; image[42526]=225; image[42527]=251; image[42528]=255; image[42529]=255; image[42530]=255; image[42531]=255; image[42532]=255; image[42533]=255; image[42534]=181; image[42535]=58; image[42536]=42; image[42537]=17; image[42538]=2; image[42539]=1; image[42540]=1; image[42541]=1; image[42542]=1; image[42543]=1; image[42544]=1; image[42545]=1; image[42546]=1; image[42547]=1; image[42548]=1; image[42549]=1; image[42550]=1; image[42551]=1; image[42552]=1; image[42553]=1; image[42554]=0; image[42555]=1; image[42556]=1; image[42557]=1; image[42558]=1; image[42559]=1; image[42560]=0; image[42561]=1; image[42562]=1; image[42563]=1; image[42564]=1; image[42565]=1; image[42566]=1; image[42567]=1; image[42568]=1; image[42569]=1; image[42570]=1; image[42571]=1; image[42572]=1; image[42573]=1; image[42574]=1; image[42575]=1; image[42576]=1; image[42577]=1; image[42578]=1; image[42579]=1; image[42580]=1; image[42581]=1; image[42582]=1; image[42583]=1; image[42584]=1; image[42585]=1; image[42586]=1; image[42587]=1; image[42588]=1; image[42589]=1; image[42590]=1; image[42591]=1; image[42592]=1; image[42593]=1; image[42594]=1; image[42595]=1; image[42596]=1; image[42597]=1; image[42598]=1; image[42599]=1; image[42600]=1; image[42601]=1; image[42602]=1; image[42603]=1; image[42604]=1; image[42605]=1; image[42606]=1; image[42607]=1; image[42608]=1; image[42609]=1; image[42610]=1; image[42611]=1; image[42612]=1; image[42613]=1; image[42614]=1; image[42615]=1; image[42616]=1; image[42617]=1; image[42618]=1; image[42619]=1; image[42620]=1; image[42621]=1; image[42622]=1; image[42623]=1; image[42624]=1; image[42625]=1; image[42626]=1; image[42627]=1; image[42628]=1; image[42629]=1; image[42630]=1; image[42631]=1; image[42632]=1; image[42633]=1; image[42634]=1; image[42635]=1; image[42636]=1; image[42637]=1; image[42638]=1; image[42639]=1; image[42640]=1; image[42641]=1; image[42642]=1; image[42643]=1; image[42644]=1; image[42645]=1; image[42646]=1; image[42647]=1; image[42648]=1; image[42649]=1; image[42650]=1; image[42651]=1; image[42652]=1; image[42653]=1; image[42654]=2; image[42655]=2; image[42656]=3; image[42657]=4; image[42658]=3; image[42659]=5; image[42660]=5; image[42661]=3; image[42662]=2; image[42663]=3; image[42664]=9; image[42665]=9; image[42666]=11; image[42667]=15; image[42668]=17; image[42669]=17; image[42670]=19; image[42671]=20; image[42672]=22; image[42673]=22; image[42674]=24; image[42675]=25; image[42676]=29; image[42677]=31; image[42678]=27; image[42679]=26; image[42680]=27; image[42681]=32; image[42682]=35; image[42683]=46; image[42684]=47; image[42685]=49; image[42686]=48; image[42687]=57; image[42688]=38; image[42689]=31; image[42690]=52; image[42691]=46; image[42692]=38; image[42693]=40; image[42694]=42; image[42695]=62; image[42696]=72; image[42697]=57; image[42698]=61; image[42699]=70; image[42700]=58; image[42701]=16; image[42702]=4; image[42703]=12; image[42704]=108; image[42705]=117; image[42706]=148; image[42707]=103; image[42708]=65; image[42709]=86; image[42710]=98; image[42711]=107; image[42712]=111; image[42713]=116; image[42714]=115; image[42715]=115; image[42716]=123; image[42717]=115; image[42718]=59; image[42719]=71; image[42720]=63; image[42721]=68; image[42722]=84; image[42723]=169; image[42724]=222; image[42725]=224; image[42726]=251; image[42727]=255; image[42728]=255; image[42729]=255; image[42730]=255; image[42731]=255; image[42732]=252; image[42733]=156; image[42734]=47; image[42735]=34; image[42736]=10; image[42737]=1; image[42738]=1; image[42739]=1; image[42740]=1; image[42741]=1; image[42742]=1; image[42743]=1; image[42744]=1; image[42745]=1; image[42746]=1; image[42747]=1; image[42748]=1; image[42749]=1; image[42750]=1; image[42751]=1; image[42752]=1; image[42753]=0; image[42754]=1; image[42755]=1; image[42756]=1; image[42757]=1; image[42758]=1; image[42759]=1; image[42760]=1; image[42761]=1; image[42762]=1; image[42763]=1; image[42764]=1; image[42765]=1; image[42766]=1; image[42767]=1; image[42768]=1; image[42769]=1; image[42770]=1; image[42771]=1; image[42772]=1; image[42773]=1; image[42774]=1; image[42775]=1; image[42776]=1; image[42777]=1; image[42778]=1; image[42779]=1; image[42780]=1; image[42781]=1; image[42782]=1; image[42783]=1; image[42784]=1; image[42785]=1; image[42786]=1; image[42787]=1; image[42788]=1; image[42789]=1; image[42790]=1; image[42791]=1; image[42792]=1; image[42793]=1; image[42794]=1; image[42795]=1; image[42796]=1; image[42797]=1; image[42798]=1; image[42799]=1; image[42800]=1; image[42801]=1; image[42802]=1; image[42803]=1; image[42804]=1; image[42805]=1; image[42806]=1; image[42807]=1; image[42808]=1; image[42809]=1; image[42810]=1; image[42811]=1; image[42812]=1; image[42813]=1; image[42814]=1; image[42815]=1; image[42816]=1; image[42817]=1; image[42818]=1; image[42819]=1; image[42820]=1; image[42821]=1; image[42822]=1; image[42823]=1; image[42824]=1; image[42825]=1; image[42826]=1; image[42827]=1; image[42828]=1; image[42829]=1; image[42830]=1; image[42831]=1; image[42832]=1; image[42833]=1; image[42834]=1; image[42835]=1; image[42836]=1; image[42837]=1; image[42838]=1; image[42839]=1; image[42840]=1; image[42841]=1; image[42842]=1; image[42843]=1; image[42844]=1; image[42845]=1; image[42846]=1; image[42847]=1; image[42848]=1; image[42849]=1; image[42850]=1; image[42851]=1; image[42852]=1; image[42853]=1; image[42854]=2; image[42855]=3; image[42856]=3; image[42857]=4; image[42858]=4; image[42859]=3; image[42860]=2; image[42861]=3; image[42862]=5; image[42863]=7; image[42864]=8; image[42865]=12; image[42866]=16; image[42867]=18; image[42868]=18; image[42869]=18; image[42870]=21; image[42871]=22; image[42872]=23; image[42873]=27; image[42874]=25; image[42875]=29; image[42876]=29; image[42877]=32; image[42878]=31; image[42879]=32; image[42880]=34; image[42881]=37; image[42882]=38; image[42883]=42; image[42884]=68; image[42885]=60; image[42886]=51; image[42887]=32; image[42888]=30; image[42889]=45; image[42890]=46; image[42891]=39; image[42892]=45; image[42893]=43; image[42894]=54; image[42895]=63; image[42896]=56; image[42897]=67; image[42898]=57; image[42899]=33; image[42900]=8; image[42901]=4; image[42902]=15; image[42903]=189; image[42904]=189; image[42905]=118; image[42906]=83; image[42907]=69; image[42908]=94; image[42909]=93; image[42910]=95; image[42911]=121; image[42912]=116; image[42913]=108; image[42914]=111; image[42915]=107; image[42916]=130; image[42917]=71; image[42918]=70; image[42919]=65; image[42920]=70; image[42921]=95; image[42922]=176; image[42923]=208; image[42924]=227; image[42925]=252; image[42926]=255; image[42927]=255; image[42928]=255; image[42929]=255; image[42930]=255; image[42931]=245; image[42932]=122; image[42933]=43; image[42934]=27; image[42935]=7; image[42936]=1; image[42937]=1; image[42938]=1; image[42939]=1; image[42940]=1; image[42941]=1; image[42942]=1; image[42943]=1; image[42944]=1; image[42945]=1; image[42946]=1; image[42947]=1; image[42948]=1; image[42949]=1; image[42950]=1; image[42951]=1; image[42952]=1; image[42953]=1; image[42954]=1; image[42955]=1; image[42956]=1; image[42957]=1; image[42958]=1; image[42959]=1; image[42960]=1; image[42961]=1; image[42962]=1; image[42963]=1; image[42964]=1; image[42965]=1; image[42966]=1; image[42967]=1; image[42968]=1; image[42969]=1; image[42970]=1; image[42971]=1; image[42972]=1; image[42973]=1; image[42974]=1; image[42975]=1; image[42976]=1; image[42977]=1; image[42978]=1; image[42979]=1; image[42980]=1; image[42981]=1; image[42982]=1; image[42983]=1; image[42984]=1; image[42985]=1; image[42986]=1; image[42987]=1; image[42988]=1; image[42989]=1; image[42990]=1; image[42991]=1; image[42992]=1; image[42993]=1; image[42994]=1; image[42995]=1; image[42996]=1; image[42997]=1; image[42998]=1; image[42999]=1; image[43000]=1; image[43001]=1; image[43002]=1; image[43003]=1; image[43004]=1; image[43005]=1; image[43006]=1; image[43007]=1; image[43008]=1; image[43009]=1; image[43010]=1; image[43011]=1; image[43012]=1; image[43013]=1; image[43014]=1; image[43015]=1; image[43016]=1; image[43017]=1; image[43018]=1; image[43019]=1; image[43020]=1; image[43021]=1; image[43022]=1; image[43023]=1; image[43024]=1; image[43025]=1; image[43026]=1; image[43027]=1; image[43028]=1; image[43029]=1; image[43030]=1; image[43031]=1; image[43032]=1; image[43033]=1; image[43034]=1; image[43035]=1; image[43036]=1; image[43037]=1; image[43038]=1; image[43039]=1; image[43040]=1; image[43041]=1; image[43042]=1; image[43043]=1; image[43044]=1; image[43045]=1; image[43046]=1; image[43047]=1; image[43048]=2; image[43049]=1; image[43050]=1; image[43051]=2; image[43052]=2; image[43053]=1; image[43054]=3; image[43055]=4; image[43056]=4; image[43057]=4; image[43058]=2; image[43059]=1; image[43060]=4; image[43061]=6; image[43062]=7; image[43063]=9; image[43064]=11; image[43065]=12; image[43066]=14; image[43067]=17; image[43068]=18; image[43069]=19; image[43070]=21; image[43071]=22; image[43072]=26; image[43073]=26; image[43074]=27; image[43075]=28; image[43076]=30; image[43077]=29; image[43078]=32; image[43079]=34; image[43080]=36; image[43081]=37; image[43082]=36; image[43083]=44; image[43084]=63; image[43085]=58; image[43086]=28; image[43087]=43; image[43088]=44; image[43089]=40; image[43090]=34; image[43091]=42; image[43092]=42; image[43093]=58; image[43094]=66; image[43095]=62; image[43096]=69; image[43097]=41; image[43098]=17; image[43099]=8; image[43100]=4; image[43101]=17; image[43102]=134; image[43103]=144; image[43104]=111; image[43105]=91; image[43106]=95; image[43107]=95; image[43108]=93; image[43109]=97; image[43110]=112; image[43111]=107; image[43112]=107; image[43113]=114; image[43114]=145; image[43115]=141; image[43116]=72; image[43117]=75; image[43118]=72; image[43119]=77; image[43120]=107; image[43121]=174; image[43122]=209; image[43123]=245; image[43124]=255; image[43125]=255; image[43126]=255; image[43127]=255; image[43128]=255; image[43129]=255; image[43130]=221; image[43131]=60; image[43132]=37; image[43133]=25; image[43134]=5; image[43135]=1; image[43136]=1; image[43137]=1; image[43138]=1; image[43139]=1; image[43140]=1; image[43141]=1; image[43142]=1; image[43143]=1; image[43144]=1; image[43145]=1; image[43146]=1; image[43147]=1; image[43148]=1; image[43149]=1; image[43150]=1; image[43151]=1; image[43152]=1; image[43153]=1; image[43154]=1; image[43155]=1; image[43156]=1; image[43157]=1; image[43158]=1; image[43159]=1; image[43160]=1; image[43161]=1; image[43162]=1; image[43163]=1; image[43164]=1; image[43165]=1; image[43166]=1; image[43167]=1; image[43168]=1; image[43169]=1; image[43170]=1; image[43171]=1; image[43172]=1; image[43173]=1; image[43174]=1; image[43175]=1; image[43176]=1; image[43177]=1; image[43178]=1; image[43179]=1; image[43180]=1; image[43181]=1; image[43182]=1; image[43183]=1; image[43184]=1; image[43185]=1; image[43186]=1; image[43187]=1; image[43188]=1; image[43189]=1; image[43190]=1; image[43191]=1; image[43192]=1; image[43193]=1; image[43194]=1; image[43195]=1; image[43196]=1; image[43197]=1; image[43198]=1; image[43199]=1; image[43200]=1; image[43201]=1; image[43202]=1; image[43203]=1; image[43204]=1; image[43205]=1; image[43206]=1; image[43207]=1; image[43208]=1; image[43209]=1; image[43210]=1; image[43211]=1; image[43212]=1; image[43213]=1; image[43214]=1; image[43215]=1; image[43216]=1; image[43217]=1; image[43218]=1; image[43219]=1; image[43220]=1; image[43221]=1; image[43222]=1; image[43223]=1; image[43224]=1; image[43225]=1; image[43226]=1; image[43227]=1; image[43228]=1; image[43229]=1; image[43230]=1; image[43231]=1; image[43232]=1; image[43233]=1; image[43234]=1; image[43235]=1; image[43236]=1; image[43237]=1; image[43238]=1; image[43239]=1; image[43240]=1; image[43241]=1; image[43242]=1; image[43243]=1; image[43244]=1; image[43245]=1; image[43246]=1; image[43247]=1; image[43248]=1; image[43249]=1; image[43250]=1; image[43251]=2; image[43252]=2; image[43253]=3; image[43254]=3; image[43255]=3; image[43256]=2; image[43257]=1; image[43258]=3; image[43259]=4; image[43260]=5; image[43261]=6; image[43262]=8; image[43263]=11; image[43264]=12; image[43265]=14; image[43266]=16; image[43267]=19; image[43268]=20; image[43269]=24; image[43270]=21; image[43271]=23; image[43272]=28; image[43273]=28; image[43274]=27; image[43275]=28; image[43276]=29; image[43277]=32; image[43278]=35; image[43279]=36; image[43280]=38; image[43281]=35; image[43282]=31; image[43283]=34; image[43284]=31; image[43285]=27; image[43286]=44; image[43287]=42; image[43288]=40; image[43289]=35; image[43290]=43; image[43291]=38; image[43292]=56; image[43293]=63; image[43294]=58; image[43295]=63; image[43296]=32; image[43297]=10; image[43298]=11; image[43299]=4; image[43300]=22; image[43301]=144; image[43302]=119; image[43303]=95; image[43304]=75; image[43305]=99; image[43306]=80; image[43307]=89; image[43308]=98; image[43309]=104; image[43310]=116; image[43311]=116; image[43312]=113; image[43313]=174; image[43314]=132; image[43315]=71; image[43316]=83; image[43317]=74; image[43318]=72; image[43319]=111; image[43320]=178; image[43321]=222; image[43322]=244; image[43323]=255; image[43324]=255; image[43325]=255; image[43326]=255; image[43327]=255; image[43328]=255; image[43329]=184; image[43330]=55; image[43331]=39; image[43332]=15; image[43333]=3; image[43334]=1; image[43335]=1; image[43336]=1; image[43337]=1; image[43338]=1; image[43339]=1; image[43340]=1; image[43341]=1; image[43342]=1; image[43343]=1; image[43344]=1; image[43345]=1; image[43346]=1; image[43347]=1; image[43348]=1; image[43349]=1; image[43350]=1; image[43351]=1; image[43352]=1; image[43353]=1; image[43354]=1; image[43355]=1; image[43356]=1; image[43357]=1; image[43358]=1; image[43359]=1; image[43360]=1; image[43361]=1; image[43362]=1; image[43363]=1; image[43364]=1; image[43365]=1; image[43366]=1; image[43367]=1; image[43368]=1; image[43369]=1; image[43370]=1; image[43371]=1; image[43372]=1; image[43373]=1; image[43374]=1; image[43375]=1; image[43376]=1; image[43377]=0; image[43378]=1; image[43379]=1; image[43380]=1; image[43381]=1; image[43382]=1; image[43383]=1; image[43384]=1; image[43385]=1; image[43386]=1; image[43387]=1; image[43388]=1; image[43389]=1; image[43390]=1; image[43391]=1; image[43392]=1; image[43393]=1; image[43394]=1; image[43395]=1; image[43396]=1; image[43397]=1; image[43398]=1; image[43399]=1; image[43400]=1; image[43401]=1; image[43402]=1; image[43403]=1; image[43404]=1; image[43405]=1; image[43406]=1; image[43407]=1; image[43408]=1; image[43409]=1; image[43410]=1; image[43411]=1; image[43412]=1; image[43413]=1; image[43414]=1; image[43415]=1; image[43416]=1; image[43417]=1; image[43418]=1; image[43419]=1; image[43420]=1; image[43421]=1; image[43422]=1; image[43423]=1; image[43424]=1; image[43425]=1; image[43426]=1; image[43427]=1; image[43428]=1; image[43429]=1; image[43430]=1; image[43431]=1; image[43432]=1; image[43433]=1; image[43434]=1; image[43435]=1; image[43436]=1; image[43437]=1; image[43438]=1; image[43439]=1; image[43440]=1; image[43441]=1; image[43442]=1; image[43443]=1; image[43444]=2; image[43445]=1; image[43446]=1; image[43447]=2; image[43448]=2; image[43449]=1; image[43450]=2; image[43451]=3; image[43452]=3; image[43453]=3; image[43454]=3; image[43455]=2; image[43456]=1; image[43457]=4; image[43458]=3; image[43459]=3; image[43460]=6; image[43461]=6; image[43462]=9; image[43463]=11; image[43464]=12; image[43465]=13; image[43466]=14; image[43467]=18; image[43468]=22; image[43469]=20; image[43470]=19; image[43471]=24; image[43472]=28; image[43473]=31; image[43474]=26; image[43475]=27; image[43476]=31; image[43477]=35; image[43478]=36; image[43479]=39; image[43480]=37; image[43481]=46; image[43482]=37; image[43483]=18; image[43484]=36; image[43485]=52; image[43486]=43; image[43487]=39; image[43488]=34; image[43489]=45; image[43490]=42; image[43491]=60; image[43492]=61; image[43493]=63; image[43494]=55; image[43495]=23; image[43496]=13; image[43497]=33; image[43498]=12; image[43499]=19; image[43500]=152; image[43501]=152; image[43502]=125; image[43503]=71; image[43504]=79; image[43505]=81; image[43506]=87; image[43507]=104; image[43508]=118; image[43509]=116; image[43510]=116; image[43511]=112; image[43512]=156; image[43513]=108; image[43514]=88; image[43515]=104; image[43516]=73; image[43517]=65; image[43518]=121; image[43519]=213; image[43520]=254; image[43521]=253; image[43522]=255; image[43523]=255; image[43524]=255; image[43525]=255; image[43526]=255; image[43527]=255; image[43528]=195; image[43529]=59; image[43530]=48; image[43531]=11; image[43532]=2; image[43533]=1; image[43534]=1; image[43535]=1; image[43536]=1; image[43537]=1; image[43538]=1; image[43539]=1; image[43540]=1; image[43541]=1; image[43542]=1; image[43543]=1; image[43544]=1; image[43545]=1; image[43546]=1; image[43547]=1; image[43548]=1; image[43549]=1; image[43550]=1; image[43551]=1; image[43552]=1; image[43553]=1; image[43554]=1; image[43555]=1; image[43556]=1; image[43557]=1; image[43558]=1; image[43559]=1; image[43560]=1; image[43561]=1; image[43562]=1; image[43563]=1; image[43564]=1; image[43565]=1; image[43566]=0; image[43567]=1; image[43568]=1; image[43569]=1; image[43570]=1; image[43571]=1; image[43572]=1; image[43573]=1; image[43574]=1; image[43575]=1; image[43576]=1; image[43577]=1; image[43578]=1; image[43579]=1; image[43580]=1; image[43581]=1; image[43582]=1; image[43583]=1; image[43584]=1; image[43585]=1; image[43586]=1; image[43587]=1; image[43588]=1; image[43589]=1; image[43590]=1; image[43591]=1; image[43592]=1; image[43593]=1; image[43594]=1; image[43595]=1; image[43596]=1; image[43597]=1; image[43598]=1; image[43599]=1; image[43600]=1; image[43601]=1; image[43602]=1; image[43603]=1; image[43604]=1; image[43605]=1; image[43606]=1; image[43607]=1; image[43608]=1; image[43609]=1; image[43610]=1; image[43611]=1; image[43612]=1; image[43613]=1; image[43614]=1; image[43615]=1; image[43616]=1; image[43617]=1; image[43618]=1; image[43619]=1; image[43620]=1; image[43621]=1; image[43622]=1; image[43623]=1; image[43624]=1; image[43625]=1; image[43626]=1; image[43627]=1; image[43628]=1; image[43629]=1; image[43630]=1; image[43631]=1; image[43632]=1; image[43633]=1; image[43634]=1; image[43635]=1; image[43636]=1; image[43637]=1; image[43638]=1; image[43639]=1; image[43640]=1; image[43641]=1; image[43642]=1; image[43643]=2; image[43644]=1; image[43645]=1; image[43646]=1; image[43647]=1; image[43648]=1; image[43649]=2; image[43650]=2; image[43651]=3; image[43652]=3; image[43653]=3; image[43654]=1; image[43655]=1; image[43656]=1; image[43657]=2; image[43658]=2; image[43659]=4; image[43660]=5; image[43661]=7; image[43662]=10; image[43663]=11; image[43664]=12; image[43665]=16; image[43666]=17; image[43667]=15; image[43668]=17; image[43669]=21; image[43670]=20; image[43671]=21; image[43672]=23; image[43673]=24; image[43674]=25; image[43675]=24; image[43676]=31; image[43677]=35; image[43678]=38; image[43679]=42; image[43680]=45; image[43681]=32; image[43682]=18; image[43683]=41; image[43684]=57; image[43685]=44; image[43686]=42; image[43687]=36; image[43688]=44; image[43689]=47; image[43690]=65; image[43691]=58; image[43692]=64; image[43693]=51; image[43694]=17; image[43695]=12; image[43696]=50; image[43697]=27; image[43698]=12; image[43699]=94; image[43700]=121; image[43701]=89; image[43702]=74; image[43703]=80; image[43704]=94; image[43705]=94; image[43706]=95; image[43707]=108; image[43708]=106; image[43709]=109; image[43710]=114; image[43711]=147; image[43712]=120; image[43713]=98; image[43714]=94; image[43715]=62; image[43716]=62; image[43717]=136; image[43718]=218; image[43719]=242; image[43720]=250; image[43721]=255; image[43722]=255; image[43723]=255; image[43724]=255; image[43725]=255; image[43726]=255; image[43727]=123; image[43728]=34; image[43729]=30; image[43730]=8; image[43731]=1; image[43732]=1; image[43733]=1; image[43734]=1; image[43735]=1; image[43736]=1; image[43737]=1; image[43738]=1; image[43739]=1; image[43740]=1; image[43741]=1; image[43742]=1; image[43743]=1; image[43744]=1; image[43745]=1; image[43746]=1; image[43747]=1; image[43748]=1; image[43749]=1; image[43750]=1; image[43751]=1; image[43752]=1; image[43753]=1; image[43754]=1; image[43755]=1; image[43756]=1; image[43757]=1; image[43758]=1; image[43759]=1; image[43760]=1; image[43761]=1; image[43762]=1; image[43763]=1; image[43764]=1; image[43765]=1; image[43766]=1; image[43767]=1; image[43768]=1; image[43769]=1; image[43770]=1; image[43771]=1; image[43772]=1; image[43773]=1; image[43774]=1; image[43775]=1; image[43776]=1; image[43777]=1; image[43778]=1; image[43779]=1; image[43780]=1; image[43781]=1; image[43782]=1; image[43783]=1; image[43784]=1; image[43785]=1; image[43786]=1; image[43787]=1; image[43788]=1; image[43789]=1; image[43790]=1; image[43791]=1; image[43792]=1; image[43793]=1; image[43794]=1; image[43795]=1; image[43796]=1; image[43797]=1; image[43798]=1; image[43799]=1; image[43800]=1; image[43801]=1; image[43802]=1; image[43803]=1; image[43804]=1; image[43805]=1; image[43806]=1; image[43807]=1; image[43808]=1; image[43809]=1; image[43810]=1; image[43811]=1; image[43812]=1; image[43813]=1; image[43814]=1; image[43815]=1; image[43816]=1; image[43817]=1; image[43818]=1; image[43819]=1; image[43820]=1; image[43821]=1; image[43822]=1; image[43823]=1; image[43824]=1; image[43825]=1; image[43826]=1; image[43827]=1; image[43828]=1; image[43829]=1; image[43830]=1; image[43831]=1; image[43832]=1; image[43833]=1; image[43834]=1; image[43835]=1; image[43836]=1; image[43837]=2; image[43838]=1; image[43839]=1; image[43840]=1; image[43841]=1; image[43842]=1; image[43843]=1; image[43844]=2; image[43845]=1; image[43846]=1; image[43847]=1; image[43848]=3; image[43849]=3; image[43850]=3; image[43851]=3; image[43852]=3; image[43853]=1; image[43854]=2; image[43855]=1; image[43856]=1; image[43857]=1; image[43858]=2; image[43859]=4; image[43860]=6; image[43861]=9; image[43862]=10; image[43863]=12; image[43864]=14; image[43865]=14; image[43866]=14; image[43867]=14; image[43868]=14; image[43869]=13; image[43870]=14; image[43871]=18; image[43872]=20; image[43873]=19; image[43874]=20; image[43875]=25; image[43876]=28; image[43877]=34; image[43878]=38; image[43879]=40; image[43880]=32; image[43881]=20; image[43882]=43; image[43883]=55; image[43884]=44; image[43885]=38; image[43886]=36; image[43887]=44; image[43888]=49; image[43889]=69; image[43890]=61; image[43891]=62; image[43892]=44; image[43893]=15; image[43894]=14; image[43895]=67; image[43896]=46; image[43897]=14; image[43898]=96; image[43899]=145; image[43900]=63; image[43901]=67; image[43902]=92; image[43903]=95; image[43904]=95; image[43905]=93; image[43906]=99; image[43907]=104; image[43908]=106; image[43909]=108; image[43910]=131; image[43911]=145; image[43912]=109; image[43913]=78; image[43914]=56; image[43915]=71; image[43916]=145; image[43917]=201; image[43918]=232; image[43919]=255; image[43920]=255; image[43921]=255; image[43922]=255; image[43923]=255; image[43924]=255; image[43925]=255; image[43926]=75; image[43927]=33; image[43928]=22; image[43929]=6; image[43930]=1; image[43931]=1; image[43932]=1; image[43933]=1; image[43934]=1; image[43935]=1; image[43936]=1; image[43937]=1; image[43938]=1; image[43939]=1; image[43940]=1; image[43941]=1; image[43942]=1; image[43943]=1; image[43944]=1; image[43945]=1; image[43946]=1; image[43947]=1; image[43948]=1; image[43949]=1; image[43950]=1; image[43951]=1; image[43952]=1; image[43953]=1; image[43954]=1; image[43955]=1; image[43956]=1; image[43957]=1; image[43958]=1; image[43959]=1; image[43960]=1; image[43961]=1; image[43962]=1; image[43963]=1; image[43964]=1; image[43965]=1; image[43966]=1; image[43967]=1; image[43968]=1; image[43969]=1; image[43970]=1; image[43971]=1; image[43972]=1; image[43973]=1; image[43974]=1; image[43975]=1; image[43976]=1; image[43977]=1; image[43978]=1; image[43979]=1; image[43980]=1; image[43981]=1; image[43982]=1; image[43983]=1; image[43984]=1; image[43985]=1; image[43986]=1; image[43987]=1; image[43988]=1; image[43989]=1; image[43990]=1; image[43991]=1; image[43992]=1; image[43993]=1; image[43994]=1; image[43995]=1; image[43996]=1; image[43997]=1; image[43998]=1; image[43999]=1; image[44000]=1; image[44001]=1; image[44002]=1; image[44003]=1; image[44004]=1; image[44005]=1; image[44006]=1; image[44007]=1; image[44008]=1; image[44009]=1; image[44010]=1; image[44011]=1; image[44012]=1; image[44013]=1; image[44014]=1; image[44015]=1; image[44016]=1; image[44017]=1; image[44018]=1; image[44019]=1; image[44020]=1; image[44021]=1; image[44022]=1; image[44023]=1; image[44024]=1; image[44025]=1; image[44026]=1; image[44027]=1; image[44028]=1; image[44029]=1; image[44030]=1; image[44031]=1; image[44032]=1; image[44033]=1; image[44034]=1; image[44035]=1; image[44036]=1; image[44037]=1; image[44038]=1; image[44039]=1; image[44040]=1; image[44041]=1; image[44042]=2; image[44043]=1; image[44044]=2; image[44045]=2; image[44046]=1; image[44047]=2; image[44048]=5; image[44049]=5; image[44050]=3; image[44051]=2; image[44052]=2; image[44053]=2; image[44054]=3; image[44055]=3; image[44056]=3; image[44057]=3; image[44058]=2; image[44059]=2; image[44060]=3; image[44061]=3; image[44062]=6; image[44063]=8; image[44064]=9; image[44065]=11; image[44066]=15; image[44067]=15; image[44068]=8; image[44069]=10; image[44070]=12; image[44071]=13; image[44072]=15; image[44073]=19; image[44074]=24; image[44075]=28; image[44076]=32; image[44077]=35; image[44078]=40; image[44079]=28; image[44080]=18; image[44081]=51; image[44082]=52; image[44083]=44; image[44084]=39; image[44085]=38; image[44086]=42; image[44087]=51; image[44088]=64; image[44089]=62; image[44090]=62; image[44091]=42; image[44092]=19; image[44093]=15; image[44094]=80; image[44095]=74; image[44096]=37; image[44097]=98; image[44098]=158; image[44099]=80; image[44100]=70; image[44101]=95; image[44102]=96; image[44103]=103; image[44104]=100; image[44105]=103; image[44106]=106; image[44107]=100; image[44108]=114; image[44109]=127; image[44110]=117; image[44111]=104; image[44112]=72; image[44113]=49; image[44114]=72; image[44115]=143; image[44116]=204; image[44117]=233; image[44118]=255; image[44119]=255; image[44120]=255; image[44121]=255; image[44122]=255; image[44123]=255; image[44124]=227; image[44125]=67; image[44126]=37; image[44127]=17; image[44128]=3; image[44129]=1; image[44130]=1; image[44131]=1; image[44132]=1; image[44133]=1; image[44134]=1; image[44135]=1; image[44136]=1; image[44137]=1; image[44138]=1; image[44139]=1; image[44140]=1; image[44141]=1; image[44142]=1; image[44143]=1; image[44144]=1; image[44145]=1; image[44146]=1; image[44147]=1; image[44148]=1; image[44149]=1; image[44150]=1; image[44151]=1; image[44152]=1; image[44153]=1; image[44154]=1; image[44155]=1; image[44156]=0; image[44157]=1; image[44158]=1; image[44159]=1; image[44160]=1; image[44161]=1; image[44162]=1; image[44163]=1; image[44164]=1; image[44165]=1; image[44166]=1; image[44167]=1; image[44168]=1; image[44169]=1; image[44170]=1; image[44171]=1; image[44172]=1; image[44173]=1; image[44174]=1; image[44175]=1; image[44176]=1; image[44177]=1; image[44178]=1; image[44179]=1; image[44180]=1; image[44181]=1; image[44182]=1; image[44183]=1; image[44184]=1; image[44185]=1; image[44186]=1; image[44187]=1; image[44188]=1; image[44189]=1; image[44190]=1; image[44191]=1; image[44192]=1; image[44193]=1; image[44194]=1; image[44195]=1; image[44196]=1; image[44197]=1; image[44198]=1; image[44199]=1; image[44200]=1; image[44201]=1; image[44202]=1; image[44203]=1; image[44204]=1; image[44205]=1; image[44206]=1; image[44207]=1; image[44208]=1; image[44209]=1; image[44210]=1; image[44211]=1; image[44212]=1; image[44213]=1; image[44214]=1; image[44215]=1; image[44216]=1; image[44217]=1; image[44218]=1; image[44219]=1; image[44220]=1; image[44221]=1; image[44222]=1; image[44223]=1; image[44224]=1; image[44225]=1; image[44226]=1; image[44227]=1; image[44228]=1; image[44229]=1; image[44230]=1; image[44231]=1; image[44232]=1; image[44233]=1; image[44234]=1; image[44235]=1; image[44236]=1; image[44237]=1; image[44238]=1; image[44239]=1; image[44240]=1; image[44241]=1; image[44242]=1; image[44243]=1; image[44244]=1; image[44245]=1; image[44246]=3; image[44247]=6; image[44248]=5; image[44249]=3; image[44250]=1; image[44251]=2; image[44252]=2; image[44253]=4; image[44254]=4; image[44255]=3; image[44256]=6; image[44257]=10; image[44258]=12; image[44259]=9; image[44260]=7; image[44261]=6; image[44262]=7; image[44263]=7; image[44264]=8; image[44265]=10; image[44266]=10; image[44267]=7; image[44268]=7; image[44269]=9; image[44270]=12; image[44271]=13; image[44272]=15; image[44273]=16; image[44274]=17; image[44275]=28; image[44276]=31; image[44277]=32; image[44278]=19; image[44279]=18; image[44280]=52; image[44281]=51; image[44282]=44; image[44283]=37; image[44284]=41; image[44285]=40; image[44286]=59; image[44287]=61; image[44288]=62; image[44289]=58; image[44290]=50; image[44291]=29; image[44292]=13; image[44293]=69; image[44294]=66; image[44295]=57; image[44296]=97; image[44297]=139; image[44298]=98; image[44299]=82; image[44300]=94; image[44301]=91; image[44302]=101; image[44303]=105; image[44304]=107; image[44305]=106; image[44306]=98; image[44307]=116; image[44308]=124; image[44309]=105; image[44310]=94; image[44311]=62; image[44312]=49; image[44313]=82; image[44314]=167; image[44315]=219; image[44316]=248; image[44317]=255; image[44318]=255; image[44319]=255; image[44320]=255; image[44321]=255; image[44322]=255; image[44323]=171; image[44324]=52; image[44325]=39; image[44326]=12; image[44327]=2; image[44328]=1; image[44329]=1; image[44330]=1; image[44331]=1; image[44332]=1; image[44333]=1; image[44334]=1; image[44335]=1; image[44336]=1; image[44337]=1; image[44338]=1; image[44339]=1; image[44340]=1; image[44341]=1; image[44342]=1; image[44343]=1; image[44344]=1; image[44345]=1; image[44346]=1; image[44347]=1; image[44348]=1; image[44349]=1; image[44350]=1; image[44351]=1; image[44352]=1; image[44353]=1; image[44354]=1; image[44355]=1; image[44356]=1; image[44357]=1; image[44358]=1; image[44359]=1; image[44360]=1; image[44361]=1; image[44362]=1; image[44363]=1; image[44364]=1; image[44365]=1; image[44366]=1; image[44367]=1; image[44368]=1; image[44369]=1; image[44370]=1; image[44371]=1; image[44372]=1; image[44373]=1; image[44374]=1; image[44375]=1; image[44376]=1; image[44377]=1; image[44378]=1; image[44379]=1; image[44380]=1; image[44381]=1; image[44382]=1; image[44383]=1; image[44384]=1; image[44385]=1; image[44386]=1; image[44387]=1; image[44388]=1; image[44389]=1; image[44390]=1; image[44391]=1; image[44392]=1; image[44393]=1; image[44394]=1; image[44395]=1; image[44396]=1; image[44397]=1; image[44398]=1; image[44399]=1; image[44400]=1; image[44401]=1; image[44402]=1; image[44403]=1; image[44404]=1; image[44405]=1; image[44406]=1; image[44407]=1; image[44408]=1; image[44409]=1; image[44410]=1; image[44411]=1; image[44412]=1; image[44413]=1; image[44414]=1; image[44415]=1; image[44416]=1; image[44417]=1; image[44418]=1; image[44419]=1; image[44420]=1; image[44421]=1; image[44422]=1; image[44423]=1; image[44424]=1; image[44425]=1; image[44426]=1; image[44427]=1; image[44428]=1; image[44429]=1; image[44430]=1; image[44431]=1; image[44432]=1; image[44433]=1; image[44434]=1; image[44435]=1; image[44436]=1; image[44437]=1; image[44438]=2; image[44439]=1; image[44440]=1; image[44441]=1; image[44442]=1; image[44443]=1; image[44444]=2; image[44445]=4; image[44446]=5; image[44447]=5; image[44448]=3; image[44449]=1; image[44450]=2; image[44451]=2; image[44452]=3; image[44453]=4; image[44454]=6; image[44455]=9; image[44456]=10; image[44457]=14; image[44458]=21; image[44459]=22; image[44460]=23; image[44461]=24; image[44462]=24; image[44463]=23; image[44464]=28; image[44465]=28; image[44466]=24; image[44467]=22; image[44468]=20; image[44469]=17; image[44470]=12; image[44471]=12; image[44472]=17; image[44473]=18; image[44474]=20; image[44475]=24; image[44476]=28; image[44477]=15; image[44478]=23; image[44479]=51; image[44480]=45; image[44481]=43; image[44482]=36; image[44483]=45; image[44484]=40; image[44485]=63; image[44486]=60; image[44487]=68; image[44488]=61; image[44489]=68; image[44490]=34; image[44491]=9; image[44492]=71; image[44493]=81; image[44494]=70; image[44495]=125; image[44496]=139; image[44497]=97; image[44498]=88; image[44499]=91; image[44500]=92; image[44501]=103; image[44502]=102; image[44503]=101; image[44504]=113; image[44505]=100; image[44506]=105; image[44507]=108; image[44508]=105; image[44509]=90; image[44510]=50; image[44511]=47; image[44512]=93; image[44513]=172; image[44514]=208; image[44515]=255; image[44516]=255; image[44517]=255; image[44518]=255; image[44519]=255; image[44520]=255; image[44521]=255; image[44522]=146; image[44523]=40; image[44524]=28; image[44525]=7; image[44526]=2; image[44527]=1; image[44528]=1; image[44529]=1; image[44530]=1; image[44531]=1; image[44532]=1; image[44533]=1; image[44534]=1; image[44535]=1; image[44536]=1; image[44537]=1; image[44538]=1; image[44539]=1; image[44540]=1; image[44541]=1; image[44542]=1; image[44543]=1; image[44544]=1; image[44545]=1; image[44546]=1; image[44547]=1; image[44548]=1; image[44549]=1; image[44550]=1; image[44551]=1; image[44552]=1; image[44553]=1; image[44554]=1; image[44555]=1; image[44556]=1; image[44557]=1; image[44558]=1; image[44559]=1; image[44560]=1; image[44561]=1; image[44562]=1; image[44563]=1; image[44564]=1; image[44565]=1; image[44566]=1; image[44567]=1; image[44568]=1; image[44569]=1; image[44570]=1; image[44571]=1; image[44572]=1; image[44573]=1; image[44574]=1; image[44575]=1; image[44576]=1; image[44577]=1; image[44578]=1; image[44579]=1; image[44580]=1; image[44581]=1; image[44582]=1; image[44583]=1; image[44584]=1; image[44585]=1; image[44586]=1; image[44587]=1; image[44588]=1; image[44589]=1; image[44590]=1; image[44591]=1; image[44592]=1; image[44593]=1; image[44594]=1; image[44595]=1; image[44596]=1; image[44597]=1; image[44598]=1; image[44599]=1; image[44600]=1; image[44601]=1; image[44602]=1; image[44603]=1; image[44604]=1; image[44605]=1; image[44606]=1; image[44607]=1; image[44608]=1; image[44609]=1; image[44610]=1; image[44611]=1; image[44612]=1; image[44613]=1; image[44614]=1; image[44615]=1; image[44616]=1; image[44617]=1; image[44618]=1; image[44619]=1; image[44620]=1; image[44621]=1; image[44622]=1; image[44623]=1; image[44624]=1; image[44625]=1; image[44626]=1; image[44627]=1; image[44628]=1; image[44629]=1; image[44630]=1; image[44631]=1; image[44632]=1; image[44633]=1; image[44634]=1; image[44635]=1; image[44636]=1; image[44637]=1; image[44638]=1; image[44639]=1; image[44640]=1; image[44641]=1; image[44642]=1; image[44643]=2; image[44644]=4; image[44645]=5; image[44646]=5; image[44647]=2; image[44648]=1; image[44649]=1; image[44650]=2; image[44651]=3; image[44652]=2; image[44653]=4; image[44654]=9; image[44655]=11; image[44656]=14; image[44657]=16; image[44658]=18; image[44659]=20; image[44660]=22; image[44661]=25; image[44662]=31; image[44663]=34; image[44664]=35; image[44665]=37; image[44666]=40; image[44667]=45; image[44668]=45; image[44669]=39; image[44670]=19; image[44671]=10; image[44672]=9; image[44673]=13; image[44674]=17; image[44675]=24; image[44676]=12; image[44677]=24; image[44678]=50; image[44679]=41; image[44680]=42; image[44681]=36; image[44682]=46; image[44683]=41; image[44684]=64; image[44685]=59; image[44686]=68; image[44687]=60; image[44688]=59; image[44689]=21; image[44690]=6; image[44691]=66; image[44692]=80; image[44693]=65; image[44694]=122; image[44695]=137; image[44696]=110; image[44697]=101; image[44698]=97; image[44699]=93; image[44700]=103; image[44701]=99; image[44702]=100; image[44703]=111; image[44704]=89; image[44705]=103; image[44706]=117; image[44707]=101; image[44708]=80; image[44709]=39; image[44710]=44; image[44711]=104; image[44712]=170; image[44713]=202; image[44714]=239; image[44715]=255; image[44716]=255; image[44717]=255; image[44718]=255; image[44719]=255; image[44720]=246; image[44721]=90; image[44722]=39; image[44723]=20; image[44724]=6; image[44725]=1; image[44726]=1; image[44727]=1; image[44728]=1; image[44729]=1; image[44730]=1; image[44731]=1; image[44732]=1; image[44733]=1; image[44734]=1; image[44735]=1; image[44736]=1; image[44737]=1; image[44738]=1; image[44739]=1; image[44740]=1; image[44741]=0; image[44742]=1; image[44743]=1; image[44744]=1; image[44745]=1; image[44746]=1; image[44747]=1; image[44748]=1; image[44749]=1; image[44750]=1; image[44751]=1; image[44752]=1; image[44753]=1; image[44754]=1; image[44755]=1; image[44756]=1; image[44757]=1; image[44758]=1; image[44759]=1; image[44760]=1; image[44761]=1; image[44762]=0; image[44763]=1; image[44764]=1; image[44765]=1; image[44766]=1; image[44767]=1; image[44768]=1; image[44769]=1; image[44770]=1; image[44771]=1; image[44772]=1; image[44773]=1; image[44774]=1; image[44775]=1; image[44776]=1; image[44777]=1; image[44778]=1; image[44779]=1; image[44780]=1; image[44781]=1; image[44782]=1; image[44783]=1; image[44784]=1; image[44785]=1; image[44786]=1; image[44787]=1; image[44788]=1; image[44789]=1; image[44790]=1; image[44791]=1; image[44792]=1; image[44793]=1; image[44794]=1; image[44795]=1; image[44796]=1; image[44797]=1; image[44798]=1; image[44799]=1; image[44800]=1; image[44801]=1; image[44802]=1; image[44803]=1; image[44804]=1; image[44805]=1; image[44806]=1; image[44807]=1; image[44808]=1; image[44809]=1; image[44810]=1; image[44811]=1; image[44812]=1; image[44813]=1; image[44814]=1; image[44815]=1; image[44816]=1; image[44817]=1; image[44818]=1; image[44819]=1; image[44820]=1; image[44821]=1; image[44822]=1; image[44823]=1; image[44824]=1; image[44825]=1; image[44826]=1; image[44827]=1; image[44828]=1; image[44829]=1; image[44830]=1; image[44831]=1; image[44832]=1; image[44833]=1; image[44834]=1; image[44835]=1; image[44836]=1; image[44837]=1; image[44838]=1; image[44839]=1; image[44840]=1; image[44841]=1; image[44842]=1; image[44843]=5; image[44844]=4; image[44845]=4; image[44846]=2; image[44847]=1; image[44848]=2; image[44849]=2; image[44850]=2; image[44851]=1; image[44852]=2; image[44853]=5; image[44854]=8; image[44855]=10; image[44856]=14; image[44857]=18; image[44858]=24; image[44859]=23; image[44860]=23; image[44861]=27; image[44862]=31; image[44863]=35; image[44864]=32; image[44865]=33; image[44866]=40; image[44867]=45; image[44868]=52; image[44869]=60; image[44870]=28; image[44871]=5; image[44872]=4; image[44873]=4; image[44874]=8; image[44875]=8; image[44876]=33; image[44877]=50; image[44878]=42; image[44879]=40; image[44880]=35; image[44881]=42; image[44882]=42; image[44883]=61; image[44884]=62; image[44885]=74; image[44886]=57; image[44887]=46; image[44888]=11; image[44889]=4; image[44890]=56; image[44891]=72; image[44892]=58; image[44893]=105; image[44894]=120; image[44895]=109; image[44896]=104; image[44897]=100; image[44898]=93; image[44899]=98; image[44900]=99; image[44901]=109; image[44902]=111; image[44903]=103; image[44904]=119; image[44905]=113; image[44906]=104; image[44907]=77; image[44908]=32; image[44909]=36; image[44910]=112; image[44911]=183; image[44912]=205; image[44913]=231; image[44914]=253; image[44915]=255; image[44916]=255; image[44917]=255; image[44918]=252; image[44919]=162; image[44920]=53; image[44921]=42; image[44922]=18; image[44923]=4; image[44924]=1; image[44925]=1; image[44926]=1; image[44927]=1; image[44928]=1; image[44929]=1; image[44930]=1; image[44931]=1; image[44932]=1; image[44933]=1; image[44934]=1; image[44935]=1; image[44936]=1; image[44937]=1; image[44938]=1; image[44939]=1; image[44940]=1; image[44941]=1; image[44942]=1; image[44943]=1; image[44944]=1; image[44945]=1; image[44946]=1; image[44947]=1; image[44948]=1; image[44949]=1; image[44950]=1; image[44951]=1; image[44952]=1; image[44953]=1; image[44954]=1; image[44955]=1; image[44956]=1; image[44957]=1; image[44958]=1; image[44959]=1; image[44960]=1; image[44961]=1; image[44962]=1; image[44963]=1; image[44964]=1; image[44965]=1; image[44966]=1; image[44967]=1; image[44968]=1; image[44969]=1; image[44970]=1; image[44971]=1; image[44972]=1; image[44973]=1; image[44974]=1; image[44975]=1; image[44976]=1; image[44977]=1; image[44978]=1; image[44979]=1; image[44980]=1; image[44981]=1; image[44982]=1; image[44983]=1; image[44984]=1; image[44985]=1; image[44986]=1; image[44987]=1; image[44988]=1; image[44989]=1; image[44990]=1; image[44991]=1; image[44992]=1; image[44993]=1; image[44994]=1; image[44995]=1; image[44996]=1; image[44997]=1; image[44998]=1; image[44999]=1; image[45000]=1; image[45001]=1; image[45002]=1; image[45003]=1; image[45004]=1; image[45005]=1; image[45006]=1; image[45007]=1; image[45008]=1; image[45009]=1; image[45010]=1; image[45011]=1; image[45012]=1; image[45013]=1; image[45014]=1; image[45015]=1; image[45016]=1; image[45017]=1; image[45018]=1; image[45019]=1; image[45020]=1; image[45021]=1; image[45022]=1; image[45023]=1; image[45024]=1; image[45025]=1; image[45026]=1; image[45027]=1; image[45028]=1; image[45029]=1; image[45030]=1; image[45031]=1; image[45032]=1; image[45033]=1; image[45034]=1; image[45035]=1; image[45036]=1; image[45037]=1; image[45038]=1; image[45039]=2; image[45040]=2; image[45041]=2; image[45042]=5; image[45043]=4; image[45044]=6; image[45045]=3; image[45046]=2; image[45047]=2; image[45048]=2; image[45049]=2; image[45050]=2; image[45051]=2; image[45052]=3; image[45053]=4; image[45054]=5; image[45055]=5; image[45056]=5; image[45057]=9; image[45058]=23; image[45059]=30; image[45060]=30; image[45061]=32; image[45062]=35; image[45063]=36; image[45064]=35; image[45065]=43; image[45066]=44; image[45067]=42; image[45068]=59; image[45069]=43; image[45070]=13; image[45071]=7; image[45072]=5; image[45073]=3; image[45074]=11; image[45075]=49; image[45076]=50; image[45077]=43; image[45078]=37; image[45079]=41; image[45080]=43; image[45081]=48; image[45082]=65; image[45083]=62; image[45084]=67; image[45085]=55; image[45086]=45; image[45087]=10; image[45088]=3; image[45089]=47; image[45090]=70; image[45091]=48; image[45092]=85; image[45093]=109; image[45094]=110; image[45095]=111; image[45096]=91; image[45097]=88; image[45098]=92; image[45099]=99; image[45100]=112; image[45101]=108; image[45102]=123; image[45103]=120; image[45104]=93; image[45105]=105; image[45106]=67; image[45107]=26; image[45108]=38; image[45109]=129; image[45110]=181; image[45111]=182; image[45112]=232; image[45113]=251; image[45114]=255; image[45115]=255; image[45116]=255; image[45117]=233; image[45118]=103; image[45119]=47; image[45120]=33; image[45121]=13; image[45122]=3; image[45123]=1; image[45124]=1; image[45125]=1; image[45126]=1; image[45127]=1; image[45128]=1; image[45129]=1; image[45130]=1; image[45131]=1; image[45132]=1; image[45133]=1; image[45134]=1; image[45135]=1; image[45136]=1; image[45137]=1; image[45138]=1; image[45139]=1; image[45140]=1; image[45141]=1; image[45142]=1; image[45143]=1; image[45144]=1; image[45145]=1; image[45146]=1; image[45147]=1; image[45148]=1; image[45149]=1; image[45150]=1; image[45151]=1; image[45152]=1; image[45153]=1; image[45154]=1; image[45155]=1; image[45156]=1; image[45157]=1; image[45158]=1; image[45159]=1; image[45160]=1; image[45161]=1; image[45162]=1; image[45163]=1; image[45164]=1; image[45165]=1; image[45166]=1; image[45167]=1; image[45168]=1; image[45169]=1; image[45170]=1; image[45171]=1; image[45172]=1; image[45173]=1; image[45174]=1; image[45175]=1; image[45176]=1; image[45177]=1; image[45178]=1; image[45179]=1; image[45180]=1; image[45181]=1; image[45182]=1; image[45183]=1; image[45184]=1; image[45185]=1; image[45186]=1; image[45187]=1; image[45188]=1; image[45189]=1; image[45190]=1; image[45191]=1; image[45192]=1; image[45193]=1; image[45194]=1; image[45195]=1; image[45196]=1; image[45197]=1; image[45198]=1; image[45199]=1; image[45200]=1; image[45201]=1; image[45202]=1; image[45203]=1; image[45204]=1; image[45205]=1; image[45206]=1; image[45207]=1; image[45208]=1; image[45209]=1; image[45210]=1; image[45211]=1; image[45212]=1; image[45213]=1; image[45214]=1; image[45215]=1; image[45216]=1; image[45217]=1; image[45218]=1; image[45219]=1; image[45220]=1; image[45221]=1; image[45222]=1; image[45223]=1; image[45224]=1; image[45225]=1; image[45226]=1; image[45227]=1; image[45228]=1; image[45229]=1; image[45230]=1; image[45231]=1; image[45232]=1; image[45233]=1; image[45234]=1; image[45235]=1; image[45236]=1; image[45237]=1; image[45238]=1; image[45239]=1; image[45240]=3; image[45241]=4; image[45242]=3; image[45243]=6; image[45244]=2; image[45245]=1; image[45246]=1; image[45247]=2; image[45248]=5; image[45249]=7; image[45250]=9; image[45251]=12; image[45252]=12; image[45253]=13; image[45254]=14; image[45255]=11; image[45256]=6; image[45257]=7; image[45258]=13; image[45259]=28; image[45260]=36; image[45261]=36; image[45262]=33; image[45263]=33; image[45264]=41; image[45265]=44; image[45266]=45; image[45267]=59; image[45268]=49; image[45269]=15; image[45270]=6; image[45271]=6; image[45272]=4; image[45273]=19; image[45274]=55; image[45275]=46; image[45276]=40; image[45277]=36; image[45278]=48; image[45279]=39; image[45280]=51; image[45281]=69; image[45282]=63; image[45283]=61; image[45284]=51; image[45285]=22; image[45286]=5; image[45287]=4; image[45288]=40; image[45289]=55; image[45290]=33; image[45291]=65; image[45292]=97; image[45293]=115; image[45294]=105; image[45295]=86; image[45296]=87; image[45297]=86; image[45298]=93; image[45299]=104; image[45300]=102; image[45301]=106; image[45302]=106; image[45303]=94; image[45304]=95; image[45305]=50; image[45306]=21; image[45307]=54; image[45308]=137; image[45309]=168; image[45310]=182; image[45311]=231; image[45312]=247; image[45313]=255; image[45314]=255; image[45315]=255; image[45316]=241; image[45317]=115; image[45318]=66; image[45319]=30; image[45320]=8; image[45321]=2; image[45322]=1; image[45323]=1; image[45324]=1; image[45325]=1; image[45326]=1; image[45327]=1; image[45328]=0; image[45329]=1; image[45330]=1; image[45331]=1; image[45332]=1; image[45333]=1; image[45334]=1; image[45335]=1; image[45336]=1; image[45337]=1; image[45338]=1; image[45339]=1; image[45340]=1; image[45341]=1; image[45342]=1; image[45343]=1; image[45344]=1; image[45345]=1; image[45346]=1; image[45347]=1; image[45348]=1; image[45349]=1; image[45350]=1; image[45351]=1; image[45352]=1; image[45353]=1; image[45354]=1; image[45355]=1; image[45356]=1; image[45357]=1; image[45358]=1; image[45359]=1; image[45360]=1; image[45361]=1; image[45362]=1; image[45363]=1; image[45364]=1; image[45365]=1; image[45366]=1; image[45367]=1; image[45368]=1; image[45369]=1; image[45370]=1; image[45371]=1; image[45372]=1; image[45373]=1; image[45374]=1; image[45375]=1; image[45376]=1; image[45377]=1; image[45378]=1; image[45379]=1; image[45380]=1; image[45381]=1; image[45382]=1; image[45383]=1; image[45384]=1; image[45385]=1; image[45386]=1; image[45387]=1; image[45388]=1; image[45389]=1; image[45390]=1; image[45391]=1; image[45392]=1; image[45393]=1; image[45394]=1; image[45395]=1; image[45396]=1; image[45397]=1; image[45398]=1; image[45399]=1; image[45400]=1; image[45401]=1; image[45402]=1; image[45403]=1; image[45404]=1; image[45405]=1; image[45406]=1; image[45407]=1; image[45408]=1; image[45409]=1; image[45410]=1; image[45411]=1; image[45412]=1; image[45413]=1; image[45414]=1; image[45415]=1; image[45416]=1; image[45417]=1; image[45418]=1; image[45419]=1; image[45420]=1; image[45421]=1; image[45422]=1; image[45423]=1; image[45424]=1; image[45425]=1; image[45426]=1; image[45427]=1; image[45428]=1; image[45429]=1; image[45430]=1; image[45431]=1; image[45432]=1; image[45433]=1; image[45434]=1; image[45435]=1; image[45436]=1; image[45437]=1; image[45438]=2; image[45439]=3; image[45440]=4; image[45441]=3; image[45442]=5; image[45443]=3; image[45444]=1; image[45445]=2; image[45446]=3; image[45447]=6; image[45448]=9; image[45449]=10; image[45450]=12; image[45451]=15; image[45452]=17; image[45453]=21; image[45454]=22; image[45455]=21; image[45456]=14; image[45457]=10; image[45458]=7; image[45459]=15; image[45460]=27; image[45461]=35; image[45462]=38; image[45463]=47; image[45464]=42; image[45465]=45; image[45466]=56; image[45467]=39; image[45468]=16; image[45469]=8; image[45470]=8; image[45471]=3; image[45472]=26; image[45473]=55; image[45474]=40; image[45475]=38; image[45476]=35; image[45477]=44; image[45478]=36; image[45479]=53; image[45480]=62; image[45481]=64; image[45482]=54; image[45483]=44; image[45484]=10; image[45485]=3; image[45486]=4; image[45487]=34; image[45488]=45; image[45489]=32; image[45490]=64; image[45491]=92; image[45492]=119; image[45493]=90; image[45494]=85; image[45495]=84; image[45496]=83; image[45497]=98; image[45498]=109; image[45499]=109; image[45500]=97; image[45501]=100; image[45502]=99; image[45503]=81; image[45504]=37; image[45505]=17; image[45506]=66; image[45507]=144; image[45508]=155; image[45509]=178; image[45510]=224; image[45511]=253; image[45512]=255; image[45513]=255; image[45514]=255; image[45515]=228; image[45516]=88; image[45517]=46; image[45518]=25; image[45519]=6; image[45520]=1; image[45521]=1; image[45522]=1; image[45523]=1; image[45524]=1; image[45525]=1; image[45526]=1; image[45527]=1; image[45528]=1; image[45529]=1; image[45530]=1; image[45531]=1; image[45532]=1; image[45533]=1; image[45534]=1; image[45535]=1; image[45536]=1; image[45537]=1; image[45538]=1; image[45539]=1; image[45540]=1; image[45541]=1; image[45542]=1; image[45543]=1; image[45544]=1; image[45545]=1; image[45546]=1; image[45547]=1; image[45548]=1; image[45549]=1; image[45550]=1; image[45551]=1; image[45552]=1; image[45553]=1; image[45554]=1; image[45555]=1; image[45556]=1; image[45557]=1; image[45558]=1; image[45559]=1; image[45560]=1; image[45561]=1; image[45562]=1; image[45563]=1; image[45564]=1; image[45565]=1; image[45566]=1; image[45567]=1; image[45568]=1; image[45569]=1; image[45570]=1; image[45571]=1; image[45572]=1; image[45573]=1; image[45574]=1; image[45575]=1; image[45576]=1; image[45577]=1; image[45578]=1; image[45579]=1; image[45580]=1; image[45581]=1; image[45582]=1; image[45583]=1; image[45584]=1; image[45585]=1; image[45586]=1; image[45587]=1; image[45588]=1; image[45589]=1; image[45590]=1; image[45591]=1; image[45592]=1; image[45593]=1; image[45594]=1; image[45595]=1; image[45596]=1; image[45597]=1; image[45598]=1; image[45599]=1; image[45600]=1; image[45601]=1; image[45602]=1; image[45603]=1; image[45604]=1; image[45605]=1; image[45606]=1; image[45607]=1; image[45608]=1; image[45609]=1; image[45610]=1; image[45611]=1; image[45612]=1; image[45613]=1; image[45614]=1; image[45615]=1; image[45616]=1; image[45617]=1; image[45618]=1; image[45619]=1; image[45620]=1; image[45621]=1; image[45622]=1; image[45623]=1; image[45624]=1; image[45625]=1; image[45626]=1; image[45627]=1; image[45628]=1; image[45629]=1; image[45630]=2; image[45631]=1; image[45632]=1; image[45633]=1; image[45634]=1; image[45635]=1; image[45636]=1; image[45637]=3; image[45638]=4; image[45639]=3; image[45640]=3; image[45641]=4; image[45642]=3; image[45643]=3; image[45644]=5; image[45645]=6; image[45646]=7; image[45647]=8; image[45648]=8; image[45649]=9; image[45650]=11; image[45651]=13; image[45652]=15; image[45653]=17; image[45654]=20; image[45655]=24; image[45656]=29; image[45657]=28; image[45658]=18; image[45659]=10; image[45660]=11; image[45661]=14; image[45662]=21; image[45663]=22; image[45664]=25; image[45665]=25; image[45666]=12; image[45667]=7; image[45668]=5; image[45669]=5; image[45670]=3; image[45671]=31; image[45672]=50; image[45673]=41; image[45674]=43; image[45675]=33; image[45676]=36; image[45677]=30; image[45678]=51; image[45679]=59; image[45680]=66; image[45681]=46; image[45682]=30; image[45683]=7; image[45684]=4; image[45685]=5; image[45686]=48; image[45687]=52; image[45688]=24; image[45689]=50; image[45690]=100; image[45691]=117; image[45692]=76; image[45693]=85; image[45694]=91; image[45695]=93; image[45696]=99; image[45697]=105; image[45698]=96; image[45699]=91; image[45700]=103; image[45701]=110; image[45702]=74; image[45703]=32; image[45704]=18; image[45705]=74; image[45706]=153; image[45707]=146; image[45708]=172; image[45709]=206; image[45710]=243; image[45711]=255; image[45712]=255; image[45713]=255; image[45714]=201; image[45715]=62; image[45716]=36; image[45717]=17; image[45718]=4; image[45719]=1; image[45720]=1; image[45721]=1; image[45722]=1; image[45723]=1; image[45724]=1; image[45725]=1; image[45726]=1; image[45727]=1; image[45728]=1; image[45729]=1; image[45730]=1; image[45731]=1; image[45732]=1; image[45733]=1; image[45734]=1; image[45735]=1; image[45736]=1; image[45737]=1; image[45738]=1; image[45739]=1; image[45740]=1; image[45741]=0; image[45742]=1; image[45743]=1; image[45744]=1; image[45745]=1; image[45746]=1; image[45747]=1; image[45748]=1; image[45749]=1; image[45750]=1; image[45751]=1; image[45752]=1; image[45753]=1; image[45754]=1; image[45755]=1; image[45756]=1; image[45757]=1; image[45758]=1; image[45759]=1; image[45760]=1; image[45761]=1; image[45762]=1; image[45763]=1; image[45764]=1; image[45765]=1; image[45766]=1; image[45767]=1; image[45768]=1; image[45769]=1; image[45770]=1; image[45771]=1; image[45772]=1; image[45773]=1; image[45774]=1; image[45775]=1; image[45776]=1; image[45777]=1; image[45778]=1; image[45779]=1; image[45780]=1; image[45781]=1; image[45782]=1; image[45783]=1; image[45784]=1; image[45785]=1; image[45786]=1; image[45787]=1; image[45788]=1; image[45789]=1; image[45790]=1; image[45791]=1; image[45792]=1; image[45793]=1; image[45794]=1; image[45795]=1; image[45796]=1; image[45797]=1; image[45798]=1; image[45799]=1; image[45800]=1; image[45801]=1; image[45802]=1; image[45803]=1; image[45804]=1; image[45805]=1; image[45806]=1; image[45807]=1; image[45808]=1; image[45809]=1; image[45810]=1; image[45811]=1; image[45812]=1; image[45813]=1; image[45814]=1; image[45815]=1; image[45816]=1; image[45817]=1; image[45818]=1; image[45819]=1; image[45820]=1; image[45821]=1; image[45822]=1; image[45823]=1; image[45824]=1; image[45825]=1; image[45826]=1; image[45827]=1; image[45828]=1; image[45829]=1; image[45830]=1; image[45831]=1; image[45832]=1; image[45833]=1; image[45834]=1; image[45835]=1; image[45836]=3; image[45837]=4; image[45838]=3; image[45839]=3; image[45840]=3; image[45841]=2; image[45842]=2; image[45843]=5; image[45844]=7; image[45845]=8; image[45846]=8; image[45847]=9; image[45848]=11; image[45849]=12; image[45850]=14; image[45851]=16; image[45852]=18; image[45853]=18; image[45854]=19; image[45855]=22; image[45856]=26; image[45857]=29; image[45858]=31; image[45859]=29; image[45860]=24; image[45861]=15; image[45862]=11; image[45863]=8; image[45864]=4; image[45865]=4; image[45866]=3; image[45867]=2; image[45868]=2; image[45869]=5; image[45870]=39; image[45871]=41; image[45872]=35; image[45873]=41; image[45874]=41; image[45875]=43; image[45876]=36; image[45877]=55; image[45878]=66; image[45879]=65; image[45880]=40; image[45881]=20; image[45882]=4; image[45883]=3; image[45884]=6; image[45885]=45; image[45886]=48; image[45887]=25; image[45888]=41; image[45889]=88; image[45890]=88; image[45891]=71; image[45892]=94; image[45893]=95; image[45894]=99; image[45895]=107; image[45896]=105; image[45897]=91; image[45898]=100; image[45899]=108; image[45900]=109; image[45901]=63; image[45902]=24; image[45903]=20; image[45904]=80; image[45905]=143; image[45906]=128; image[45907]=174; image[45908]=217; image[45909]=243; image[45910]=255; image[45911]=255; image[45912]=254; image[45913]=171; image[45914]=52; image[45915]=32; image[45916]=12; image[45917]=3; image[45918]=1; image[45919]=1; image[45920]=1; image[45921]=1; image[45922]=1; image[45923]=1; image[45924]=1; image[45925]=1; image[45926]=1; image[45927]=1; image[45928]=1; image[45929]=1; image[45930]=1; image[45931]=1; image[45932]=1; image[45933]=1; image[45934]=1; image[45935]=1; image[45936]=1; image[45937]=1; image[45938]=1; image[45939]=1; image[45940]=1; image[45941]=1; image[45942]=1; image[45943]=1; image[45944]=1; image[45945]=1; image[45946]=1; image[45947]=1; image[45948]=1; image[45949]=1; image[45950]=1; image[45951]=1; image[45952]=1; image[45953]=1; image[45954]=1; image[45955]=1; image[45956]=1; image[45957]=1; image[45958]=1; image[45959]=1; image[45960]=1; image[45961]=1; image[45962]=1; image[45963]=1; image[45964]=1; image[45965]=1; image[45966]=1; image[45967]=1; image[45968]=1; image[45969]=1; image[45970]=1; image[45971]=1; image[45972]=1; image[45973]=1; image[45974]=1; image[45975]=1; image[45976]=1; image[45977]=1; image[45978]=1; image[45979]=1; image[45980]=1; image[45981]=1; image[45982]=1; image[45983]=1; image[45984]=1; image[45985]=1; image[45986]=1; image[45987]=1; image[45988]=1; image[45989]=1; image[45990]=1; image[45991]=1; image[45992]=1; image[45993]=1; image[45994]=1; image[45995]=1; image[45996]=1; image[45997]=1; image[45998]=1; image[45999]=1; image[46000]=1; image[46001]=1; image[46002]=1; image[46003]=1; image[46004]=1; image[46005]=1; image[46006]=1; image[46007]=1; image[46008]=1; image[46009]=1; image[46010]=1; image[46011]=1; image[46012]=1; image[46013]=1; image[46014]=1; image[46015]=1; image[46016]=1; image[46017]=1; image[46018]=1; image[46019]=1; image[46020]=1; image[46021]=1; image[46022]=1; image[46023]=1; image[46024]=1; image[46025]=1; image[46026]=1; image[46027]=1; image[46028]=1; image[46029]=1; image[46030]=1; image[46031]=1; image[46032]=1; image[46033]=1; image[46034]=2; image[46035]=3; image[46036]=3; image[46037]=3; image[46038]=2; image[46039]=2; image[46040]=1; image[46041]=2; image[46042]=5; image[46043]=6; image[46044]=6; image[46045]=8; image[46046]=10; image[46047]=13; image[46048]=14; image[46049]=14; image[46050]=14; image[46051]=15; image[46052]=16; image[46053]=24; image[46054]=28; image[46055]=26; image[46056]=24; image[46057]=27; image[46058]=37; image[46059]=42; image[46060]=41; image[46061]=44; image[46062]=43; image[46063]=39; image[46064]=32; image[46065]=17; image[46066]=8; image[46067]=5; image[46068]=10; image[46069]=44; image[46070]=39; image[46071]=36; image[46072]=40; image[46073]=43; image[46074]=38; image[46075]=32; image[46076]=59; image[46077]=67; image[46078]=51; image[46079]=23; image[46080]=12; image[46081]=3; image[46082]=3; image[46083]=7; image[46084]=29; image[46085]=26; image[46086]=25; image[46087]=47; image[46088]=74; image[46089]=72; image[46090]=82; image[46091]=102; image[46092]=96; image[46093]=95; image[46094]=102; image[46095]=99; image[46096]=97; image[46097]=102; image[46098]=103; image[46099]=97; image[46100]=51; image[46101]=17; image[46102]=28; image[46103]=107; image[46104]=139; image[46105]=111; image[46106]=157; image[46107]=213; image[46108]=251; image[46109]=253; image[46110]=255; image[46111]=238; image[46112]=101; image[46113]=41; image[46114]=32; image[46115]=9; image[46116]=2; image[46117]=1; image[46118]=1; image[46119]=1; image[46120]=1; image[46121]=1; image[46122]=1; image[46123]=1; image[46124]=1; image[46125]=1; image[46126]=1; image[46127]=1; image[46128]=1; image[46129]=1; image[46130]=1; image[46131]=1; image[46132]=1; image[46133]=1; image[46134]=1; image[46135]=1; image[46136]=1; image[46137]=1; image[46138]=1; image[46139]=1; image[46140]=1; image[46141]=1; image[46142]=1; image[46143]=1; image[46144]=1; image[46145]=1; image[46146]=1; image[46147]=1; image[46148]=1; image[46149]=1; image[46150]=1; image[46151]=1; image[46152]=1; image[46153]=1; image[46154]=0; image[46155]=1; image[46156]=1; image[46157]=1; image[46158]=1; image[46159]=1; image[46160]=1; image[46161]=1; image[46162]=1; image[46163]=1; image[46164]=1; image[46165]=1; image[46166]=1; image[46167]=1; image[46168]=1; image[46169]=1; image[46170]=1; image[46171]=1; image[46172]=1; image[46173]=1; image[46174]=1; image[46175]=1; image[46176]=1; image[46177]=1; image[46178]=1; image[46179]=1; image[46180]=1; image[46181]=1; image[46182]=1; image[46183]=1; image[46184]=1; image[46185]=1; image[46186]=1; image[46187]=1; image[46188]=1; image[46189]=1; image[46190]=1; image[46191]=1; image[46192]=1; image[46193]=1; image[46194]=1; image[46195]=1; image[46196]=1; image[46197]=1; image[46198]=1; image[46199]=1; image[46200]=1; image[46201]=1; image[46202]=1; image[46203]=1; image[46204]=1; image[46205]=1; image[46206]=1; image[46207]=1; image[46208]=1; image[46209]=1; image[46210]=1; image[46211]=1; image[46212]=1; image[46213]=1; image[46214]=1; image[46215]=1; image[46216]=1; image[46217]=1; image[46218]=1; image[46219]=1; image[46220]=1; image[46221]=1; image[46222]=1; image[46223]=1; image[46224]=1; image[46225]=1; image[46226]=1; image[46227]=1; image[46228]=1; image[46229]=1; image[46230]=1; image[46231]=1; image[46232]=1; image[46233]=2; image[46234]=3; image[46235]=3; image[46236]=3; image[46237]=4; image[46238]=5; image[46239]=2; image[46240]=2; image[46241]=5; image[46242]=6; image[46243]=8; image[46244]=10; image[46245]=11; image[46246]=13; image[46247]=13; image[46248]=13; image[46249]=15; image[46250]=15; image[46251]=19; image[46252]=23; image[46253]=24; image[46254]=29; image[46255]=28; image[46256]=30; image[46257]=28; image[46258]=29; image[46259]=28; image[46260]=33; image[46261]=36; image[46262]=40; image[46263]=45; image[46264]=47; image[46265]=29; image[46266]=11; image[46267]=16; image[46268]=42; image[46269]=31; image[46270]=40; image[46271]=42; image[46272]=35; image[46273]=36; image[46274]=39; image[46275]=61; image[46276]=57; image[46277]=37; image[46278]=18; image[46279]=11; image[46280]=4; image[46281]=3; image[46282]=11; image[46283]=36; image[46284]=25; image[46285]=30; image[46286]=68; image[46287]=78; image[46288]=79; image[46289]=96; image[46290]=105; image[46291]=105; image[46292]=94; image[46293]=100; image[46294]=93; image[46295]=103; image[46296]=112; image[46297]=106; image[46298]=90; image[46299]=42; image[46300]=13; image[46301]=34; image[46302]=131; image[46303]=138; image[46304]=118; image[46305]=155; image[46306]=203; image[46307]=255; image[46308]=231; image[46309]=232; image[46310]=204; image[46311]=81; image[46312]=38; image[46313]=23; image[46314]=6; image[46315]=2; image[46316]=1; image[46317]=1; image[46318]=1; image[46319]=1; image[46320]=1; image[46321]=1; image[46322]=1; image[46323]=1; image[46324]=1; image[46325]=1; image[46326]=1; image[46327]=1; image[46328]=1; image[46329]=1; image[46330]=1; image[46331]=1; image[46332]=1; image[46333]=1; image[46334]=1; image[46335]=1; image[46336]=1; image[46337]=1; image[46338]=1; image[46339]=1; image[46340]=1; image[46341]=1; image[46342]=1; image[46343]=1; image[46344]=1; image[46345]=1; image[46346]=1; image[46347]=1; image[46348]=1; image[46349]=1; image[46350]=1; image[46351]=1; image[46352]=1; image[46353]=0; image[46354]=1; image[46355]=1; image[46356]=1; image[46357]=1; image[46358]=1; image[46359]=1; image[46360]=1; image[46361]=1; image[46362]=1; image[46363]=1; image[46364]=1; image[46365]=1; image[46366]=1; image[46367]=1; image[46368]=1; image[46369]=1; image[46370]=1; image[46371]=1; image[46372]=1; image[46373]=1; image[46374]=1; image[46375]=1; image[46376]=1; image[46377]=1; image[46378]=1; image[46379]=1; image[46380]=1; image[46381]=1; image[46382]=1; image[46383]=1; image[46384]=1; image[46385]=1; image[46386]=1; image[46387]=1; image[46388]=1; image[46389]=1; image[46390]=1; image[46391]=1; image[46392]=1; image[46393]=1; image[46394]=1; image[46395]=1; image[46396]=1; image[46397]=1; image[46398]=1; image[46399]=1; image[46400]=1; image[46401]=1; image[46402]=1; image[46403]=1; image[46404]=1; image[46405]=1; image[46406]=1; image[46407]=1; image[46408]=1; image[46409]=1; image[46410]=1; image[46411]=1; image[46412]=1; image[46413]=1; image[46414]=1; image[46415]=1; image[46416]=1; image[46417]=1; image[46418]=1; image[46419]=1; image[46420]=1; image[46421]=1; image[46422]=1; image[46423]=1; image[46424]=1; image[46425]=1; image[46426]=1; image[46427]=1; image[46428]=1; image[46429]=1; image[46430]=1; image[46431]=1; image[46432]=2; image[46433]=3; image[46434]=2; image[46435]=4; image[46436]=8; image[46437]=7; image[46438]=2; image[46439]=1; image[46440]=5; image[46441]=6; image[46442]=6; image[46443]=9; image[46444]=11; image[46445]=11; image[46446]=12; image[46447]=14; image[46448]=15; image[46449]=15; image[46450]=18; image[46451]=20; image[46452]=23; image[46453]=27; image[46454]=27; image[46455]=29; image[46456]=31; image[46457]=31; image[46458]=30; image[46459]=35; image[46460]=38; image[46461]=38; image[46462]=37; image[46463]=43; image[46464]=20; image[46465]=10; image[46466]=31; image[46467]=41; image[46468]=28; image[46469]=40; image[46470]=40; image[46471]=36; image[46472]=37; image[46473]=42; image[46474]=65; image[46475]=52; image[46476]=30; image[46477]=21; image[46478]=11; image[46479]=5; image[46480]=5; image[46481]=16; image[46482]=30; image[46483]=22; image[46484]=37; image[46485]=89; image[46486]=91; image[46487]=86; image[46488]=102; image[46489]=106; image[46490]=105; image[46491]=92; image[46492]=90; image[46493]=82; image[46494]=100; image[46495]=114; image[46496]=104; image[46497]=77; image[46498]=32; image[46499]=11; image[46500]=42; image[46501]=115; image[46502]=105; image[46503]=118; image[46504]=159; image[46505]=186; image[46506]=226; image[46507]=232; image[46508]=238; image[46509]=149; image[46510]=60; image[46511]=37; image[46512]=13; image[46513]=4; image[46514]=1; image[46515]=1; image[46516]=1; image[46517]=1; image[46518]=1; image[46519]=1; image[46520]=1; image[46521]=1; image[46522]=1; image[46523]=1; image[46524]=1; image[46525]=1; image[46526]=1; image[46527]=1; image[46528]=1; image[46529]=1; image[46530]=1; image[46531]=1; image[46532]=1; image[46533]=1; image[46534]=1; image[46535]=0; image[46536]=1; image[46537]=1; image[46538]=1; image[46539]=1; image[46540]=1; image[46541]=1; image[46542]=1; image[46543]=1; image[46544]=1; image[46545]=1; image[46546]=1; image[46547]=1; image[46548]=1; image[46549]=1; image[46550]=1; image[46551]=1; image[46552]=1; image[46553]=1; image[46554]=1; image[46555]=1; image[46556]=1; image[46557]=1; image[46558]=1; image[46559]=1; image[46560]=1; image[46561]=1; image[46562]=1; image[46563]=1; image[46564]=1; image[46565]=1; image[46566]=1; image[46567]=1; image[46568]=1; image[46569]=1; image[46570]=1; image[46571]=1; image[46572]=1; image[46573]=1; image[46574]=1; image[46575]=1; image[46576]=1; image[46577]=1; image[46578]=1; image[46579]=1; image[46580]=1; image[46581]=1; image[46582]=1; image[46583]=1; image[46584]=1; image[46585]=1; image[46586]=1; image[46587]=1; image[46588]=1; image[46589]=1; image[46590]=1; image[46591]=1; image[46592]=1; image[46593]=1; image[46594]=1; image[46595]=1; image[46596]=1; image[46597]=1; image[46598]=1; image[46599]=1; image[46600]=1; image[46601]=1; image[46602]=1; image[46603]=1; image[46604]=1; image[46605]=1; image[46606]=1; image[46607]=1; image[46608]=1; image[46609]=1; image[46610]=1; image[46611]=1; image[46612]=1; image[46613]=1; image[46614]=1; image[46615]=1; image[46616]=1; image[46617]=1; image[46618]=1; image[46619]=1; image[46620]=1; image[46621]=1; image[46622]=1; image[46623]=1; image[46624]=1; image[46625]=1; image[46626]=1; image[46627]=1; image[46628]=1; image[46629]=1; image[46630]=1; image[46631]=2; image[46632]=2; image[46633]=2; image[46634]=6; image[46635]=11; image[46636]=5; image[46637]=2; image[46638]=3; image[46639]=5; image[46640]=5; image[46641]=8; image[46642]=9; image[46643]=9; image[46644]=10; image[46645]=11; image[46646]=13; image[46647]=15; image[46648]=15; image[46649]=17; image[46650]=20; image[46651]=23; image[46652]=21; image[46653]=24; image[46654]=26; image[46655]=32; image[46656]=30; image[46657]=24; image[46658]=26; image[46659]=28; image[46660]=35; image[46661]=38; image[46662]=42; image[46663]=11; image[46664]=16; image[46665]=46; image[46666]=41; image[46667]=32; image[46668]=40; image[46669]=37; image[46670]=38; image[46671]=34; image[46672]=41; image[46673]=69; image[46674]=43; image[46675]=30; image[46676]=26; image[46677]=9; image[46678]=8; image[46679]=17; image[46680]=48; image[46681]=57; image[46682]=38; image[46683]=60; image[46684]=107; image[46685]=106; image[46686]=103; image[46687]=99; image[46688]=96; image[46689]=93; image[46690]=95; image[46691]=81; image[46692]=86; image[46693]=103; image[46694]=104; image[46695]=109; image[46696]=74; image[46697]=23; image[46698]=12; image[46699]=52; image[46700]=98; image[46701]=90; image[46702]=105; image[46703]=150; image[46704]=189; image[46705]=233; image[46706]=222; image[46707]=216; image[46708]=142; image[46709]=60; image[46710]=27; image[46711]=10; image[46712]=2; image[46713]=1; image[46714]=1; image[46715]=1; image[46716]=1; image[46717]=1; image[46718]=1; image[46719]=1; image[46720]=1; image[46721]=1; image[46722]=1; image[46723]=1; image[46724]=1; image[46725]=1; image[46726]=1; image[46727]=1; image[46728]=1; image[46729]=1; image[46730]=1; image[46731]=1; image[46732]=1; image[46733]=0; image[46734]=1; image[46735]=1; image[46736]=0; image[46737]=1; image[46738]=1; image[46739]=1; image[46740]=1; image[46741]=1; image[46742]=1; image[46743]=1; image[46744]=1; image[46745]=1; image[46746]=1; image[46747]=1; image[46748]=1; image[46749]=1; image[46750]=1; image[46751]=1; image[46752]=1; image[46753]=1; image[46754]=1; image[46755]=1; image[46756]=1; image[46757]=1; image[46758]=1; image[46759]=1; image[46760]=1; image[46761]=1; image[46762]=1; image[46763]=1; image[46764]=1; image[46765]=1; image[46766]=1; image[46767]=1; image[46768]=1; image[46769]=1; image[46770]=1; image[46771]=1; image[46772]=1; image[46773]=1; image[46774]=1; image[46775]=1; image[46776]=1; image[46777]=1; image[46778]=1; image[46779]=1; image[46780]=1; image[46781]=1; image[46782]=1; image[46783]=1; image[46784]=1; image[46785]=1; image[46786]=1; image[46787]=1; image[46788]=1; image[46789]=1; image[46790]=1; image[46791]=1; image[46792]=1; image[46793]=1; image[46794]=1; image[46795]=1; image[46796]=1; image[46797]=1; image[46798]=1; image[46799]=1; image[46800]=1; image[46801]=1; image[46802]=1; image[46803]=1; image[46804]=1; image[46805]=1; image[46806]=1; image[46807]=1; image[46808]=1; image[46809]=1; image[46810]=1; image[46811]=1; image[46812]=1; image[46813]=1; image[46814]=1; image[46815]=1; image[46816]=1; image[46817]=1; image[46818]=1; image[46819]=1; image[46820]=1; image[46821]=1; image[46822]=1; image[46823]=1; image[46824]=1; image[46825]=1; image[46826]=1; image[46827]=1; image[46828]=1; image[46829]=1; image[46830]=2; image[46831]=2; image[46832]=2; image[46833]=5; image[46834]=7; image[46835]=3; image[46836]=2; image[46837]=3; image[46838]=4; image[46839]=6; image[46840]=8; image[46841]=10; image[46842]=10; image[46843]=10; image[46844]=11; image[46845]=12; image[46846]=14; image[46847]=14; image[46848]=16; image[46849]=22; image[46850]=24; image[46851]=23; image[46852]=25; image[46853]=28; image[46854]=30; image[46855]=30; image[46856]=31; image[46857]=29; image[46858]=30; image[46859]=37; image[46860]=40; image[46861]=32; image[46862]=9; image[46863]=21; image[46864]=42; image[46865]=38; image[46866]=30; image[46867]=38; image[46868]=34; image[46869]=40; image[46870]=34; image[46871]=44; image[46872]=61; image[46873]=31; image[46874]=22; image[46875]=18; image[46876]=10; image[46877]=29; image[46878]=99; image[46879]=144; image[46880]=76; image[46881]=54; image[46882]=93; image[46883]=134; image[46884]=138; image[46885]=111; image[46886]=92; image[46887]=100; image[46888]=93; image[46889]=88; image[46890]=75; image[46891]=89; image[46892]=100; image[46893]=96; image[46894]=102; image[46895]=61; image[46896]=16; image[46897]=15; image[46898]=57; image[46899]=91; image[46900]=89; image[46901]=118; image[46902]=149; image[46903]=185; image[46904]=245; image[46905]=252; image[46906]=161; image[46907]=70; image[46908]=44; image[46909]=25; image[46910]=8; image[46911]=2; image[46912]=1; image[46913]=1; image[46914]=1; image[46915]=1; image[46916]=1; image[46917]=1; image[46918]=1; image[46919]=1; image[46920]=1; image[46921]=1; image[46922]=1; image[46923]=1; image[46924]=1; image[46925]=1; image[46926]=1; image[46927]=1; image[46928]=1; image[46929]=1; image[46930]=1; image[46931]=1; image[46932]=1; image[46933]=1; image[46934]=1; image[46935]=1; image[46936]=1; image[46937]=1; image[46938]=1; image[46939]=1; image[46940]=1; image[46941]=1; image[46942]=1; image[46943]=1; image[46944]=1; image[46945]=1; image[46946]=1; image[46947]=1; image[46948]=1; image[46949]=1; image[46950]=1; image[46951]=1; image[46952]=1; image[46953]=1; image[46954]=1; image[46955]=1; image[46956]=1; image[46957]=1; image[46958]=1; image[46959]=1; image[46960]=1; image[46961]=1; image[46962]=1; image[46963]=1; image[46964]=1; image[46965]=1; image[46966]=1; image[46967]=1; image[46968]=1; image[46969]=1; image[46970]=1; image[46971]=1; image[46972]=1; image[46973]=1; image[46974]=1; image[46975]=1; image[46976]=1; image[46977]=1; image[46978]=1; image[46979]=1; image[46980]=1; image[46981]=1; image[46982]=1; image[46983]=1; image[46984]=1; image[46985]=1; image[46986]=1; image[46987]=1; image[46988]=1; image[46989]=1; image[46990]=1; image[46991]=1; image[46992]=1; image[46993]=1; image[46994]=1; image[46995]=1; image[46996]=1; image[46997]=1; image[46998]=1; image[46999]=1; image[47000]=1; image[47001]=1; image[47002]=1; image[47003]=1; image[47004]=1; image[47005]=1; image[47006]=1; image[47007]=1; image[47008]=1; image[47009]=1; image[47010]=1; image[47011]=1; image[47012]=1; image[47013]=1; image[47014]=1; image[47015]=1; image[47016]=1; image[47017]=1; image[47018]=1; image[47019]=1; image[47020]=1; image[47021]=1; image[47022]=1; image[47023]=1; image[47024]=1; image[47025]=1; image[47026]=1; image[47027]=1; image[47028]=1; image[47029]=2; image[47030]=2; image[47031]=2; image[47032]=2; image[47033]=2; image[47034]=2; image[47035]=2; image[47036]=4; image[47037]=5; image[47038]=8; image[47039]=8; image[47040]=9; image[47041]=10; image[47042]=12; image[47043]=13; image[47044]=13; image[47045]=14; image[47046]=15; image[47047]=20; image[47048]=21; image[47049]=23; image[47050]=24; image[47051]=25; image[47052]=29; image[47053]=30; image[47054]=28; image[47055]=28; image[47056]=34; image[47057]=35; image[47058]=39; image[47059]=36; image[47060]=21; image[47061]=15; image[47062]=30; image[47063]=39; image[47064]=34; image[47065]=31; image[47066]=40; image[47067]=33; image[47068]=40; image[47069]=32; image[47070]=47; image[47071]=53; image[47072]=23; image[47073]=13; image[47074]=10; image[47075]=12; image[47076]=64; image[47077]=177; image[47078]=167; image[47079]=70; image[47080]=60; image[47081]=94; image[47082]=134; image[47083]=140; image[47084]=96; image[47085]=89; image[47086]=94; image[47087]=83; image[47088]=79; image[47089]=78; image[47090]=87; image[47091]=95; image[47092]=107; image[47093]=96; image[47094]=49; image[47095]=14; image[47096]=19; image[47097]=58; image[47098]=92; image[47099]=90; image[47100]=123; image[47101]=140; image[47102]=189; image[47103]=243; image[47104]=238; image[47105]=147; image[47106]=67; image[47107]=37; image[47108]=20; image[47109]=6; image[47110]=1; image[47111]=1; image[47112]=1; image[47113]=1; image[47114]=1; image[47115]=1; image[47116]=1; image[47117]=1; image[47118]=1; image[47119]=1; image[47120]=1; image[47121]=1; image[47122]=1; image[47123]=1; image[47124]=1; image[47125]=1; image[47126]=1; image[47127]=1; image[47128]=1; image[47129]=0; image[47130]=1; image[47131]=1; image[47132]=1; image[47133]=1; image[47134]=1; image[47135]=1; image[47136]=1; image[47137]=1; image[47138]=1; image[47139]=1; image[47140]=1; image[47141]=1; image[47142]=1; image[47143]=1; image[47144]=1; image[47145]=1; image[47146]=1; image[47147]=1; image[47148]=1; image[47149]=1; image[47150]=1; image[47151]=1; image[47152]=1; image[47153]=1; image[47154]=1; image[47155]=1; image[47156]=1; image[47157]=1; image[47158]=1; image[47159]=1; image[47160]=1; image[47161]=1; image[47162]=1; image[47163]=1; image[47164]=1; image[47165]=1; image[47166]=1; image[47167]=1; image[47168]=1; image[47169]=1; image[47170]=1; image[47171]=1; image[47172]=1; image[47173]=1; image[47174]=1; image[47175]=1; image[47176]=1; image[47177]=1; image[47178]=1; image[47179]=1; image[47180]=1; image[47181]=1; image[47182]=1; image[47183]=1; image[47184]=1; image[47185]=1; image[47186]=1; image[47187]=1; image[47188]=1; image[47189]=1; image[47190]=1; image[47191]=1; image[47192]=1; image[47193]=1; image[47194]=1; image[47195]=1; image[47196]=1; image[47197]=1; image[47198]=1; image[47199]=1; image[47200]=1; image[47201]=1; image[47202]=1; image[47203]=1; image[47204]=1; image[47205]=1; image[47206]=1; image[47207]=1; image[47208]=1; image[47209]=1; image[47210]=1; image[47211]=1; image[47212]=1; image[47213]=1; image[47214]=1; image[47215]=1; image[47216]=1; image[47217]=1; image[47218]=1; image[47219]=1; image[47220]=1; image[47221]=1; image[47222]=1; image[47223]=1; image[47224]=1; image[47225]=1; image[47226]=1; image[47227]=1; image[47228]=3; image[47229]=3; image[47230]=3; image[47231]=3; image[47232]=2; image[47233]=1; image[47234]=2; image[47235]=4; image[47236]=6; image[47237]=7; image[47238]=7; image[47239]=8; image[47240]=9; image[47241]=11; image[47242]=11; image[47243]=12; image[47244]=14; image[47245]=18; image[47246]=29; image[47247]=23; image[47248]=22; image[47249]=22; image[47250]=23; image[47251]=29; image[47252]=32; image[47253]=29; image[47254]=31; image[47255]=35; image[47256]=32; image[47257]=27; image[47258]=20; image[47259]=13; image[47260]=21; image[47261]=32; image[47262]=40; image[47263]=35; image[47264]=35; image[47265]=40; image[47266]=35; image[47267]=40; image[47268]=35; image[47269]=54; image[47270]=42; image[47271]=14; image[47272]=13; image[47273]=9; image[47274]=20; image[47275]=135; image[47276]=163; image[47277]=86; image[47278]=61; image[47279]=61; image[47280]=81; image[47281]=115; image[47282]=108; image[47283]=84; image[47284]=85; image[47285]=86; image[47286]=84; image[47287]=80; image[47288]=80; image[47289]=100; image[47290]=99; image[47291]=105; image[47292]=87; image[47293]=38; image[47294]=10; image[47295]=23; image[47296]=67; image[47297]=88; image[47298]=91; image[47299]=122; image[47300]=147; image[47301]=189; image[47302]=224; image[47303]=228; image[47304]=127; image[47305]=53; image[47306]=28; image[47307]=14; image[47308]=5; image[47309]=1; image[47310]=1; image[47311]=1; image[47312]=1; image[47313]=1; image[47314]=1; image[47315]=1; image[47316]=1; image[47317]=1; image[47318]=1; image[47319]=1; image[47320]=1; image[47321]=1; image[47322]=1; image[47323]=1; image[47324]=1; image[47325]=1; image[47326]=1; image[47327]=1; image[47328]=1; image[47329]=1; image[47330]=1; image[47331]=1; image[47332]=1; image[47333]=1; image[47334]=1; image[47335]=1; image[47336]=1; image[47337]=1; image[47338]=1; image[47339]=0; image[47340]=1; image[47341]=1; image[47342]=1; image[47343]=1; image[47344]=1; image[47345]=1; image[47346]=1; image[47347]=1; image[47348]=1; image[47349]=1; image[47350]=1; image[47351]=1; image[47352]=1; image[47353]=1; image[47354]=1; image[47355]=1; image[47356]=1; image[47357]=1; image[47358]=1; image[47359]=1; image[47360]=1; image[47361]=1; image[47362]=1; image[47363]=1; image[47364]=1; image[47365]=1; image[47366]=1; image[47367]=1; image[47368]=1; image[47369]=1; image[47370]=1; image[47371]=1; image[47372]=1; image[47373]=1; image[47374]=1; image[47375]=1; image[47376]=1; image[47377]=1; image[47378]=1; image[47379]=1; image[47380]=1; image[47381]=1; image[47382]=1; image[47383]=1; image[47384]=1; image[47385]=1; image[47386]=1; image[47387]=1; image[47388]=1; image[47389]=1; image[47390]=1; image[47391]=1; image[47392]=1; image[47393]=1; image[47394]=1; image[47395]=1; image[47396]=1; image[47397]=1; image[47398]=1; image[47399]=1; image[47400]=1; image[47401]=1; image[47402]=1; image[47403]=1; image[47404]=1; image[47405]=1; image[47406]=1; image[47407]=1; image[47408]=1; image[47409]=1; image[47410]=1; image[47411]=1; image[47412]=1; image[47413]=1; image[47414]=1; image[47415]=1; image[47416]=1; image[47417]=1; image[47418]=1; image[47419]=1; image[47420]=1; image[47421]=1; image[47422]=1; image[47423]=1; image[47424]=1; image[47425]=1; image[47426]=2; image[47427]=2; image[47428]=3; image[47429]=4; image[47430]=2; image[47431]=1; image[47432]=2; image[47433]=3; image[47434]=6; image[47435]=6; image[47436]=6; image[47437]=7; image[47438]=9; image[47439]=9; image[47440]=11; image[47441]=12; image[47442]=13; image[47443]=14; image[47444]=15; image[47445]=21; image[47446]=19; image[47447]=19; image[47448]=21; image[47449]=24; image[47450]=30; image[47451]=32; image[47452]=34; image[47453]=38; image[47454]=28; image[47455]=25; image[47456]=24; image[47457]=18; image[47458]=16; image[47459]=28; image[47460]=34; image[47461]=39; image[47462]=32; image[47463]=34; image[47464]=38; image[47465]=34; image[47466]=38; image[47467]=35; image[47468]=57; image[47469]=34; image[47470]=9; image[47471]=10; image[47472]=10; image[47473]=52; image[47474]=152; image[47475]=94; image[47476]=49; image[47477]=69; image[47478]=73; image[47479]=73; image[47480]=81; image[47481]=70; image[47482]=74; image[47483]=78; image[47484]=79; image[47485]=79; image[47486]=76; image[47487]=93; image[47488]=97; image[47489]=95; image[47490]=102; image[47491]=76; image[47492]=27; image[47493]=9; image[47494]=30; image[47495]=84; image[47496]=94; image[47497]=94; image[47498]=123; image[47499]=152; image[47500]=194; image[47501]=213; image[47502]=215; image[47503]=123; image[47504]=44; image[47505]=28; image[47506]=13; image[47507]=3; image[47508]=1; image[47509]=1; image[47510]=1; image[47511]=1; image[47512]=1; image[47513]=1; image[47514]=1; image[47515]=1; image[47516]=1; image[47517]=1; image[47518]=1; image[47519]=1; image[47520]=1; image[47521]=1; image[47522]=1; image[47523]=1; image[47524]=1; image[47525]=1; image[47526]=1; image[47527]=1; image[47528]=1; image[47529]=1; image[47530]=1; image[47531]=1; image[47532]=1; image[47533]=1; image[47534]=1; image[47535]=1; image[47536]=1; image[47537]=1; image[47538]=1; image[47539]=1; image[47540]=1; image[47541]=1; image[47542]=1; image[47543]=1; image[47544]=1; image[47545]=1; image[47546]=1; image[47547]=1; image[47548]=1; image[47549]=1; image[47550]=1; image[47551]=1; image[47552]=1; image[47553]=1; image[47554]=1; image[47555]=1; image[47556]=1; image[47557]=1; image[47558]=1; image[47559]=1; image[47560]=1; image[47561]=1; image[47562]=1; image[47563]=1; image[47564]=1; image[47565]=1; image[47566]=1; image[47567]=1; image[47568]=1; image[47569]=1; image[47570]=1; image[47571]=1; image[47572]=1; image[47573]=1; image[47574]=1; image[47575]=1; image[47576]=1; image[47577]=1; image[47578]=1; image[47579]=1; image[47580]=1; image[47581]=1; image[47582]=1; image[47583]=1; image[47584]=1; image[47585]=1; image[47586]=1; image[47587]=1; image[47588]=1; image[47589]=1; image[47590]=1; image[47591]=1; image[47592]=1; image[47593]=1; image[47594]=1; image[47595]=1; image[47596]=1; image[47597]=1; image[47598]=1; image[47599]=1; image[47600]=1; image[47601]=1; image[47602]=1; image[47603]=1; image[47604]=1; image[47605]=1; image[47606]=1; image[47607]=1; image[47608]=1; image[47609]=1; image[47610]=1; image[47611]=1; image[47612]=1; image[47613]=1; image[47614]=1; image[47615]=1; image[47616]=1; image[47617]=1; image[47618]=1; image[47619]=1; image[47620]=1; image[47621]=1; image[47622]=1; image[47623]=1; image[47624]=2; image[47625]=2; image[47626]=2; image[47627]=2; image[47628]=4; image[47629]=2; image[47630]=1; image[47631]=2; image[47632]=4; image[47633]=5; image[47634]=5; image[47635]=6; image[47636]=7; image[47637]=8; image[47638]=9; image[47639]=11; image[47640]=11; image[47641]=11; image[47642]=15; image[47643]=18; image[47644]=20; image[47645]=23; image[47646]=22; image[47647]=19; image[47648]=24; image[47649]=27; image[47650]=27; image[47651]=29; image[47652]=38; image[47653]=32; image[47654]=29; image[47655]=29; image[47656]=26; image[47657]=20; image[47658]=34; image[47659]=40; image[47660]=37; image[47661]=34; image[47662]=37; image[47663]=37; image[47664]=36; image[47665]=37; image[47666]=29; image[47667]=49; image[47668]=26; image[47669]=8; image[47670]=8; image[47671]=22; image[47672]=108; image[47673]=127; image[47674]=60; image[47675]=61; image[47676]=92; image[47677]=93; image[47678]=78; image[47679]=80; image[47680]=75; image[47681]=75; image[47682]=79; image[47683]=81; image[47684]=73; image[47685]=74; image[47686]=101; image[47687]=87; image[47688]=85; image[47689]=98; image[47690]=68; image[47691]=23; image[47692]=10; image[47693]=33; image[47694]=86; image[47695]=95; image[47696]=99; image[47697]=123; image[47698]=148; image[47699]=210; image[47700]=244; image[47701]=185; image[47702]=97; image[47703]=39; image[47704]=19; image[47705]=9; image[47706]=3; image[47707]=1; image[47708]=1; image[47709]=1; image[47710]=1; image[47711]=1; image[47712]=0; image[47713]=1; image[47714]=1; image[47715]=1; image[47716]=1; image[47717]=1; image[47718]=1; image[47719]=1; image[47720]=1; image[47721]=1; image[47722]=1; image[47723]=1; image[47724]=1; image[47725]=1; image[47726]=1; image[47727]=1; image[47728]=1; image[47729]=1; image[47730]=1; image[47731]=1; image[47732]=1; image[47733]=1; image[47734]=1; image[47735]=1; image[47736]=1; image[47737]=0; image[47738]=1; image[47739]=1; image[47740]=1; image[47741]=1; image[47742]=1; image[47743]=1; image[47744]=1; image[47745]=1; image[47746]=1; image[47747]=1; image[47748]=1; image[47749]=1; image[47750]=1; image[47751]=1; image[47752]=1; image[47753]=1; image[47754]=1; image[47755]=1; image[47756]=1; image[47757]=1; image[47758]=1; image[47759]=1; image[47760]=1; image[47761]=1; image[47762]=1; image[47763]=1; image[47764]=1; image[47765]=1; image[47766]=1; image[47767]=1; image[47768]=1; image[47769]=1; image[47770]=1; image[47771]=1; image[47772]=1; image[47773]=1; image[47774]=1; image[47775]=1; image[47776]=1; image[47777]=1; image[47778]=1; image[47779]=1; image[47780]=1; image[47781]=1; image[47782]=1; image[47783]=1; image[47784]=1; image[47785]=1; image[47786]=1; image[47787]=1; image[47788]=1; image[47789]=1; image[47790]=1; image[47791]=1; image[47792]=1; image[47793]=1; image[47794]=1; image[47795]=1; image[47796]=1; image[47797]=1; image[47798]=1; image[47799]=1; image[47800]=1; image[47801]=1; image[47802]=1; image[47803]=1; image[47804]=1; image[47805]=1; image[47806]=1; image[47807]=1; image[47808]=1; image[47809]=1; image[47810]=1; image[47811]=1; image[47812]=1; image[47813]=1; image[47814]=1; image[47815]=1; image[47816]=1; image[47817]=1; image[47818]=1; image[47819]=1; image[47820]=1; image[47821]=1; image[47822]=1; image[47823]=1; image[47824]=2; image[47825]=2; image[47826]=3; image[47827]=2; image[47828]=1; image[47829]=1; image[47830]=3; image[47831]=4; image[47832]=6; image[47833]=6; image[47834]=7; image[47835]=9; image[47836]=9; image[47837]=8; image[47838]=11; image[47839]=12; image[47840]=14; image[47841]=16; image[47842]=16; image[47843]=18; image[47844]=20; image[47845]=20; image[47846]=23; image[47847]=23; image[47848]=21; image[47849]=24; image[47850]=29; image[47851]=35; image[47852]=33; image[47853]=29; image[47854]=23; image[47855]=19; image[47856]=13; image[47857]=33; image[47858]=38; image[47859]=33; image[47860]=33; image[47861]=37; image[47862]=35; image[47863]=36; image[47864]=35; image[47865]=33; image[47866]=49; image[47867]=18; image[47868]=4; image[47869]=6; image[47870]=43; image[47871]=127; image[47872]=81; image[47873]=66; image[47874]=106; image[47875]=128; image[47876]=105; image[47877]=87; image[47878]=74; image[47879]=70; image[47880]=74; image[47881]=78; image[47882]=86; image[47883]=78; image[47884]=89; image[47885]=96; image[47886]=80; image[47887]=92; image[47888]=96; image[47889]=58; image[47890]=19; image[47891]=12; image[47892]=43; image[47893]=93; image[47894]=94; image[47895]=115; image[47896]=131; image[47897]=151; image[47898]=221; image[47899]=235; image[47900]=149; image[47901]=95; image[47902]=52; image[47903]=19; image[47904]=8; image[47905]=2; image[47906]=1; image[47907]=1; image[47908]=1; image[47909]=1; image[47910]=1; image[47911]=1; image[47912]=1; image[47913]=1; image[47914]=1; image[47915]=1; image[47916]=1; image[47917]=1; image[47918]=1; image[47919]=1; image[47920]=1; image[47921]=1; image[47922]=1; image[47923]=1; image[47924]=1; image[47925]=1; image[47926]=1; image[47927]=1; image[47928]=1; image[47929]=1; image[47930]=1; image[47931]=1; image[47932]=1; image[47933]=0; image[47934]=1; image[47935]=1; image[47936]=1; image[47937]=1; image[47938]=1; image[47939]=1; image[47940]=1; image[47941]=1; image[47942]=1; image[47943]=1; image[47944]=1; image[47945]=1; image[47946]=1; image[47947]=1; image[47948]=1; image[47949]=1; image[47950]=1; image[47951]=1; image[47952]=1; image[47953]=1; image[47954]=1; image[47955]=1; image[47956]=1; image[47957]=1; image[47958]=1; image[47959]=1; image[47960]=1; image[47961]=1; image[47962]=1; image[47963]=1; image[47964]=1; image[47965]=1; image[47966]=1; image[47967]=1; image[47968]=1; image[47969]=1; image[47970]=1; image[47971]=1; image[47972]=1; image[47973]=1; image[47974]=1; image[47975]=1; image[47976]=1; image[47977]=1; image[47978]=1; image[47979]=1; image[47980]=1; image[47981]=1; image[47982]=1; image[47983]=1; image[47984]=1; image[47985]=1; image[47986]=1; image[47987]=1; image[47988]=1; image[47989]=1; image[47990]=1; image[47991]=1; image[47992]=1; image[47993]=1; image[47994]=1; image[47995]=1; image[47996]=1; image[47997]=1; image[47998]=1; image[47999]=1; image[48000]=1; image[48001]=1; image[48002]=1; image[48003]=1; image[48004]=1; image[48005]=1; image[48006]=1; image[48007]=1; image[48008]=1; image[48009]=1; image[48010]=1; image[48011]=1; image[48012]=1; image[48013]=1; image[48014]=1; image[48015]=1; image[48016]=1; image[48017]=1; image[48018]=1; image[48019]=1; image[48020]=1; image[48021]=1; image[48022]=1; image[48023]=1; image[48024]=2; image[48025]=2; image[48026]=1; image[48027]=1; image[48028]=1; image[48029]=2; image[48030]=4; image[48031]=5; image[48032]=7; image[48033]=7; image[48034]=7; image[48035]=9; image[48036]=10; image[48037]=11; image[48038]=11; image[48039]=13; image[48040]=15; image[48041]=15; image[48042]=19; image[48043]=22; image[48044]=24; image[48045]=23; image[48046]=21; image[48047]=24; image[48048]=29; image[48049]=30; image[48050]=32; image[48051]=27; image[48052]=26; image[48053]=22; image[48054]=15; image[48055]=14; image[48056]=37; image[48057]=35; image[48058]=32; image[48059]=34; image[48060]=39; image[48061]=34; image[48062]=36; image[48063]=33; image[48064]=36; image[48065]=40; image[48066]=11; image[48067]=5; image[48068]=10; image[48069]=73; image[48070]=118; image[48071]=52; image[48072]=82; image[48073]=127; image[48074]=130; image[48075]=99; image[48076]=78; image[48077]=71; image[48078]=71; image[48079]=73; image[48080]=79; image[48081]=84; image[48082]=84; image[48083]=86; image[48084]=81; image[48085]=75; image[48086]=93; image[48087]=93; image[48088]=51; image[48089]=14; image[48090]=14; image[48091]=53; image[48092]=101; image[48093]=95; image[48094]=126; image[48095]=133; image[48096]=173; image[48097]=235; image[48098]=231; image[48099]=134; image[48100]=64; image[48101]=41; image[48102]=20; image[48103]=5; image[48104]=1; image[48105]=1; image[48106]=1; image[48107]=1; image[48108]=1; image[48109]=1; image[48110]=1; image[48111]=1; image[48112]=1; image[48113]=1; image[48114]=1; image[48115]=1; image[48116]=1; image[48117]=1; image[48118]=1; image[48119]=1; image[48120]=1; image[48121]=1; image[48122]=1; image[48123]=1; image[48124]=1; image[48125]=1; image[48126]=1; image[48127]=1; image[48128]=1; image[48129]=1; image[48130]=1; image[48131]=1; image[48132]=1; image[48133]=1; image[48134]=1; image[48135]=1; image[48136]=1; image[48137]=1; image[48138]=1; image[48139]=1; image[48140]=1; image[48141]=1; image[48142]=1; image[48143]=1; image[48144]=1; image[48145]=1; image[48146]=1; image[48147]=1; image[48148]=1; image[48149]=1; image[48150]=1; image[48151]=1; image[48152]=1; image[48153]=1; image[48154]=1; image[48155]=1; image[48156]=1; image[48157]=1; image[48158]=1; image[48159]=1; image[48160]=1; image[48161]=1; image[48162]=1; image[48163]=1; image[48164]=1; image[48165]=1; image[48166]=1; image[48167]=1; image[48168]=1; image[48169]=1; image[48170]=1; image[48171]=1; image[48172]=1; image[48173]=1; image[48174]=1; image[48175]=1; image[48176]=1; image[48177]=1; image[48178]=1; image[48179]=1; image[48180]=1; image[48181]=1; image[48182]=1; image[48183]=1; image[48184]=1; image[48185]=1; image[48186]=1; image[48187]=1; image[48188]=1; image[48189]=1; image[48190]=1; image[48191]=1; image[48192]=1; image[48193]=1; image[48194]=1; image[48195]=1; image[48196]=1; image[48197]=1; image[48198]=1; image[48199]=1; image[48200]=1; image[48201]=1; image[48202]=1; image[48203]=1; image[48204]=1; image[48205]=1; image[48206]=1; image[48207]=1; image[48208]=1; image[48209]=1; image[48210]=1; image[48211]=1; image[48212]=1; image[48213]=1; image[48214]=1; image[48215]=1; image[48216]=1; image[48217]=1; image[48218]=1; image[48219]=1; image[48220]=1; image[48221]=1; image[48222]=1; image[48223]=2; image[48224]=2; image[48225]=1; image[48226]=1; image[48227]=2; image[48228]=3; image[48229]=3; image[48230]=4; image[48231]=6; image[48232]=6; image[48233]=5; image[48234]=8; image[48235]=9; image[48236]=10; image[48237]=11; image[48238]=13; image[48239]=17; image[48240]=17; image[48241]=20; image[48242]=22; image[48243]=23; image[48244]=21; image[48245]=21; image[48246]=24; image[48247]=29; image[48248]=29; image[48249]=31; image[48250]=30; image[48251]=24; image[48252]=23; image[48253]=17; image[48254]=18; image[48255]=36; image[48256]=31; image[48257]=29; image[48258]=34; image[48259]=39; image[48260]=32; image[48261]=40; image[48262]=31; image[48263]=38; image[48264]=33; image[48265]=6; image[48266]=6; image[48267]=21; image[48268]=112; image[48269]=118; image[48270]=58; image[48271]=96; image[48272]=124; image[48273]=131; image[48274]=94; image[48275]=79; image[48276]=82; image[48277]=70; image[48278]=76; image[48279]=101; image[48280]=99; image[48281]=86; image[48282]=71; image[48283]=73; image[48284]=85; image[48285]=95; image[48286]=86; image[48287]=47; image[48288]=12; image[48289]=17; image[48290]=58; image[48291]=103; image[48292]=104; image[48293]=132; image[48294]=147; image[48295]=195; image[48296]=214; image[48297]=199; image[48298]=157; image[48299]=64; image[48300]=31; image[48301]=16; image[48302]=4; image[48303]=1; image[48304]=1; image[48305]=1; image[48306]=1; image[48307]=1; image[48308]=1; image[48309]=1; image[48310]=1; image[48311]=1; image[48312]=1; image[48313]=1; image[48314]=1; image[48315]=1; image[48316]=1; image[48317]=1; image[48318]=1; image[48319]=1; image[48320]=1; image[48321]=1; image[48322]=1; image[48323]=1; image[48324]=1; image[48325]=1; image[48326]=1; image[48327]=1; image[48328]=1; image[48329]=1; image[48330]=1; image[48331]=1; image[48332]=1; image[48333]=1; image[48334]=1; image[48335]=1; image[48336]=1; image[48337]=1; image[48338]=1; image[48339]=1; image[48340]=1; image[48341]=1; image[48342]=1; image[48343]=1; image[48344]=1; image[48345]=1; image[48346]=1; image[48347]=1; image[48348]=1; image[48349]=1; image[48350]=1; image[48351]=1; image[48352]=1; image[48353]=1; image[48354]=1; image[48355]=1; image[48356]=1; image[48357]=1; image[48358]=1; image[48359]=1; image[48360]=1; image[48361]=1; image[48362]=1; image[48363]=1; image[48364]=1; image[48365]=1; image[48366]=1; image[48367]=1; image[48368]=1; image[48369]=1; image[48370]=1; image[48371]=1; image[48372]=1; image[48373]=1; image[48374]=1; image[48375]=1; image[48376]=1; image[48377]=1; image[48378]=1; image[48379]=1; image[48380]=1; image[48381]=1; image[48382]=1; image[48383]=1; image[48384]=1; image[48385]=1; image[48386]=1; image[48387]=1; image[48388]=1; image[48389]=1; image[48390]=1; image[48391]=1; image[48392]=1; image[48393]=1; image[48394]=1; image[48395]=1; image[48396]=1; image[48397]=1; image[48398]=1; image[48399]=1; image[48400]=1; image[48401]=1; image[48402]=1; image[48403]=1; image[48404]=1; image[48405]=1; image[48406]=1; image[48407]=1; image[48408]=1; image[48409]=1; image[48410]=1; image[48411]=1; image[48412]=1; image[48413]=1; image[48414]=1; image[48415]=1; image[48416]=1; image[48417]=1; image[48418]=1; image[48419]=1; image[48420]=1; image[48421]=1; image[48422]=2; image[48423]=1; image[48424]=1; image[48425]=1; image[48426]=2; image[48427]=3; image[48428]=3; image[48429]=4; image[48430]=4; image[48431]=5; image[48432]=5; image[48433]=7; image[48434]=8; image[48435]=9; image[48436]=11; image[48437]=14; image[48438]=16; image[48439]=18; image[48440]=18; image[48441]=19; image[48442]=21; image[48443]=21; image[48444]=23; image[48445]=25; image[48446]=25; image[48447]=25; image[48448]=27; image[48449]=28; image[48450]=26; image[48451]=27; image[48452]=21; image[48453]=27; image[48454]=32; image[48455]=27; image[48456]=30; image[48457]=34; image[48458]=38; image[48459]=32; image[48460]=38; image[48461]=30; image[48462]=35; image[48463]=21; image[48464]=3; image[48465]=5; image[48466]=36; image[48467]=130; image[48468]=87; image[48469]=55; image[48470]=90; image[48471]=120; image[48472]=110; image[48473]=85; image[48474]=95; image[48475]=72; image[48476]=59; image[48477]=94; image[48478]=112; image[48479]=87; image[48480]=74; image[48481]=74; image[48482]=82; image[48483]=90; image[48484]=96; image[48485]=84; image[48486]=39; image[48487]=13; image[48488]=23; image[48489]=68; image[48490]=100; image[48491]=112; image[48492]=141; image[48493]=172; image[48494]=218; image[48495]=209; image[48496]=153; image[48497]=111; image[48498]=43; image[48499]=26; image[48500]=13; image[48501]=3; image[48502]=1; image[48503]=1; image[48504]=1; image[48505]=1; image[48506]=1; image[48507]=1; image[48508]=1; image[48509]=1; image[48510]=1; image[48511]=1; image[48512]=1; image[48513]=1; image[48514]=1; image[48515]=1; image[48516]=1; image[48517]=1; image[48518]=1; image[48519]=1; image[48520]=1; image[48521]=1; image[48522]=1; image[48523]=1; image[48524]=1; image[48525]=1; image[48526]=1; image[48527]=1; image[48528]=1; image[48529]=1; image[48530]=1; image[48531]=1; image[48532]=1; image[48533]=1; image[48534]=1; image[48535]=1; image[48536]=1; image[48537]=1; image[48538]=1; image[48539]=1; image[48540]=1; image[48541]=1; image[48542]=1; image[48543]=1; image[48544]=1; image[48545]=1; image[48546]=1; image[48547]=1; image[48548]=1; image[48549]=1; image[48550]=1; image[48551]=1; image[48552]=1; image[48553]=1; image[48554]=1; image[48555]=1; image[48556]=1; image[48557]=1; image[48558]=1; image[48559]=1; image[48560]=1; image[48561]=1; image[48562]=1; image[48563]=1; image[48564]=1; image[48565]=1; image[48566]=1; image[48567]=1; image[48568]=1; image[48569]=1; image[48570]=1; image[48571]=1; image[48572]=1; image[48573]=1; image[48574]=1; image[48575]=1; image[48576]=1; image[48577]=1; image[48578]=1; image[48579]=1; image[48580]=1; image[48581]=1; image[48582]=1; image[48583]=1; image[48584]=1; image[48585]=1; image[48586]=1; image[48587]=1; image[48588]=1; image[48589]=1; image[48590]=1; image[48591]=1; image[48592]=1; image[48593]=1; image[48594]=1; image[48595]=1; image[48596]=1; image[48597]=1; image[48598]=1; image[48599]=1; image[48600]=1; image[48601]=1; image[48602]=1; image[48603]=1; image[48604]=1; image[48605]=1; image[48606]=1; image[48607]=1; image[48608]=1; image[48609]=1; image[48610]=1; image[48611]=1; image[48612]=1; image[48613]=1; image[48614]=1; image[48615]=1; image[48616]=1; image[48617]=1; image[48618]=1; image[48619]=1; image[48620]=2; image[48621]=1; image[48622]=1; image[48623]=1; image[48624]=1; image[48625]=2; image[48626]=1; image[48627]=2; image[48628]=3; image[48629]=3; image[48630]=4; image[48631]=5; image[48632]=7; image[48633]=7; image[48634]=8; image[48635]=9; image[48636]=12; image[48637]=13; image[48638]=14; image[48639]=17; image[48640]=17; image[48641]=18; image[48642]=19; image[48643]=23; image[48644]=26; image[48645]=26; image[48646]=27; image[48647]=29; image[48648]=28; image[48649]=29; image[48650]=16; image[48651]=16; image[48652]=36; image[48653]=33; image[48654]=28; image[48655]=32; image[48656]=37; image[48657]=36; image[48658]=31; image[48659]=36; image[48660]=31; image[48661]=30; image[48662]=12; image[48663]=2; image[48664]=2; image[48665]=31; image[48666]=109; image[48667]=68; image[48668]=69; image[48669]=74; image[48670]=79; image[48671]=107; image[48672]=111; image[48673]=86; image[48674]=55; image[48675]=65; image[48676]=79; image[48677]=82; image[48678]=79; image[48679]=79; image[48680]=72; image[48681]=83; image[48682]=88; image[48683]=86; image[48684]=73; image[48685]=29; image[48686]=11; image[48687]=33; image[48688]=87; image[48689]=107; image[48690]=112; image[48691]=150; image[48692]=184; image[48693]=204; image[48694]=218; image[48695]=189; image[48696]=113; image[48697]=30; image[48698]=17; image[48699]=10; image[48700]=3; image[48701]=1; image[48702]=1; image[48703]=1; image[48704]=1; image[48705]=1; image[48706]=1; image[48707]=1; image[48708]=1; image[48709]=1; image[48710]=1; image[48711]=1; image[48712]=1; image[48713]=1; image[48714]=1; image[48715]=1; image[48716]=1; image[48717]=1; image[48718]=1; image[48719]=1; image[48720]=1; image[48721]=1; image[48722]=1; image[48723]=1; image[48724]=1; image[48725]=1; image[48726]=1; image[48727]=1; image[48728]=1; image[48729]=1; image[48730]=1; image[48731]=1; image[48732]=1; image[48733]=1; image[48734]=1; image[48735]=1; image[48736]=1; image[48737]=0; image[48738]=1; image[48739]=1; image[48740]=1; image[48741]=1; image[48742]=1; image[48743]=1; image[48744]=1; image[48745]=1; image[48746]=1; image[48747]=1; image[48748]=1; image[48749]=1; image[48750]=1; image[48751]=1; image[48752]=1; image[48753]=1; image[48754]=1; image[48755]=1; image[48756]=1; image[48757]=1; image[48758]=1; image[48759]=1; image[48760]=1; image[48761]=1; image[48762]=1; image[48763]=1; image[48764]=1; image[48765]=1; image[48766]=1; image[48767]=1; image[48768]=1; image[48769]=1; image[48770]=1; image[48771]=1; image[48772]=1; image[48773]=1; image[48774]=1; image[48775]=1; image[48776]=1; image[48777]=1; image[48778]=1; image[48779]=1; image[48780]=1; image[48781]=1; image[48782]=1; image[48783]=1; image[48784]=1; image[48785]=1; image[48786]=1; image[48787]=1; image[48788]=1; image[48789]=1; image[48790]=1; image[48791]=1; image[48792]=1; image[48793]=1; image[48794]=1; image[48795]=1; image[48796]=1; image[48797]=1; image[48798]=1; image[48799]=1; image[48800]=1; image[48801]=1; image[48802]=1; image[48803]=1; image[48804]=1; image[48805]=1; image[48806]=1; image[48807]=1; image[48808]=1; image[48809]=1; image[48810]=1; image[48811]=1; image[48812]=1; image[48813]=1; image[48814]=1; image[48815]=1; image[48816]=1; image[48817]=1; image[48818]=1; image[48819]=1; image[48820]=1; image[48821]=1; image[48822]=1; image[48823]=1; image[48824]=1; image[48825]=1; image[48826]=2; image[48827]=2; image[48828]=3; image[48829]=4; image[48830]=4; image[48831]=4; image[48832]=5; image[48833]=7; image[48834]=7; image[48835]=9; image[48836]=11; image[48837]=12; image[48838]=15; image[48839]=15; image[48840]=15; image[48841]=18; image[48842]=21; image[48843]=22; image[48844]=23; image[48845]=25; image[48846]=27; image[48847]=22; image[48848]=21; image[48849]=19; image[48850]=23; image[48851]=35; image[48852]=31; image[48853]=28; image[48854]=32; image[48855]=38; image[48856]=35; image[48857]=32; image[48858]=37; image[48859]=30; image[48860]=29; image[48861]=10; image[48862]=2; image[48863]=1; image[48864]=20; image[48865]=66; image[48866]=38; image[48867]=38; image[48868]=64; image[48869]=206; image[48870]=206; image[48871]=107; image[48872]=56; image[48873]=60; image[48874]=74; image[48875]=71; image[48876]=79; image[48877]=74; image[48878]=76; image[48879]=75; image[48880]=88; image[48881]=90; image[48882]=83; image[48883]=63; image[48884]=25; image[48885]=12; image[48886]=37; image[48887]=92; image[48888]=120; image[48889]=135; image[48890]=161; image[48891]=179; image[48892]=213; image[48893]=221; image[48894]=135; image[48895]=62; image[48896]=35; image[48897]=22; image[48898]=7; image[48899]=2; image[48900]=1; image[48901]=1; image[48902]=1; image[48903]=1; image[48904]=1; image[48905]=1; image[48906]=0; image[48907]=1; image[48908]=1; image[48909]=1; image[48910]=1; image[48911]=1; image[48912]=1; image[48913]=1; image[48914]=1; image[48915]=1; image[48916]=1; image[48917]=1; image[48918]=1; image[48919]=1; image[48920]=1; image[48921]=1; image[48922]=1; image[48923]=1; image[48924]=1; image[48925]=1; image[48926]=1; image[48927]=1; image[48928]=1; image[48929]=1; image[48930]=1; image[48931]=1; image[48932]=1; image[48933]=1; image[48934]=1; image[48935]=1; image[48936]=1; image[48937]=1; image[48938]=1; image[48939]=1; image[48940]=1; image[48941]=1; image[48942]=1; image[48943]=1; image[48944]=1; image[48945]=1; image[48946]=1; image[48947]=1; image[48948]=1; image[48949]=1; image[48950]=1; image[48951]=1; image[48952]=1; image[48953]=1; image[48954]=1; image[48955]=1; image[48956]=1; image[48957]=1; image[48958]=1; image[48959]=1; image[48960]=1; image[48961]=1; image[48962]=1; image[48963]=1; image[48964]=1; image[48965]=1; image[48966]=1; image[48967]=1; image[48968]=1; image[48969]=1; image[48970]=1; image[48971]=1; image[48972]=1; image[48973]=1; image[48974]=1; image[48975]=1; image[48976]=1; image[48977]=1; image[48978]=1; image[48979]=1; image[48980]=1; image[48981]=1; image[48982]=1; image[48983]=1; image[48984]=1; image[48985]=1; image[48986]=1; image[48987]=1; image[48988]=1; image[48989]=1; image[48990]=1; image[48991]=1; image[48992]=1; image[48993]=1; image[48994]=1; image[48995]=1; image[48996]=1; image[48997]=1; image[48998]=1; image[48999]=1; image[49000]=1; image[49001]=1; image[49002]=1; image[49003]=1; image[49004]=1; image[49005]=1; image[49006]=1; image[49007]=1; image[49008]=1; image[49009]=1; image[49010]=1; image[49011]=1; image[49012]=1; image[49013]=1; image[49014]=1; image[49015]=1; image[49016]=1; image[49017]=1; image[49018]=1; image[49019]=1; image[49020]=1; image[49021]=1; image[49022]=1; image[49023]=1; image[49024]=1; image[49025]=2; image[49026]=2; image[49027]=3; image[49028]=3; image[49029]=3; image[49030]=4; image[49031]=4; image[49032]=5; image[49033]=6; image[49034]=6; image[49035]=7; image[49036]=9; image[49037]=10; image[49038]=12; image[49039]=14; image[49040]=16; image[49041]=17; image[49042]=20; image[49043]=24; image[49044]=26; image[49045]=29; image[49046]=27; image[49047]=21; image[49048]=21; image[49049]=27; image[49050]=34; image[49051]=30; image[49052]=27; image[49053]=31; image[49054]=37; image[49055]=32; image[49056]=33; image[49057]=38; image[49058]=28; image[49059]=23; image[49060]=8; image[49061]=9; image[49062]=4; image[49063]=14; image[49064]=39; image[49065]=41; image[49066]=75; image[49067]=198; image[49068]=255; image[49069]=173; image[49070]=61; image[49071]=52; image[49072]=60; image[49073]=66; image[49074]=71; image[49075]=79; image[49076]=81; image[49077]=82; image[49078]=78; image[49079]=81; image[49080]=85; image[49081]=87; image[49082]=58; image[49083]=22; image[49084]=13; image[49085]=49; image[49086]=108; image[49087]=114; image[49088]=143; image[49089]=169; image[49090]=191; image[49091]=228; image[49092]=176; image[49093]=112; image[49094]=53; image[49095]=27; image[49096]=16; image[49097]=5; image[49098]=1; image[49099]=1; image[49100]=1; image[49101]=1; image[49102]=1; image[49103]=1; image[49104]=1; image[49105]=1; image[49106]=1; image[49107]=1; image[49108]=1; image[49109]=1; image[49110]=1; image[49111]=1; image[49112]=1; image[49113]=1; image[49114]=1; image[49115]=1; image[49116]=1; image[49117]=0; image[49118]=1; image[49119]=1; image[49120]=1; image[49121]=1; image[49122]=1; image[49123]=1; image[49124]=1; image[49125]=1; image[49126]=1; image[49127]=1; image[49128]=1; image[49129]=1; image[49130]=1; image[49131]=1; image[49132]=1; image[49133]=1; image[49134]=1; image[49135]=1; image[49136]=1; image[49137]=1; image[49138]=1; image[49139]=1; image[49140]=1; image[49141]=1; image[49142]=1; image[49143]=1; image[49144]=1; image[49145]=1; image[49146]=1; image[49147]=1; image[49148]=1; image[49149]=1; image[49150]=1; image[49151]=1; image[49152]=1; image[49153]=1; image[49154]=1; image[49155]=1; image[49156]=1; image[49157]=1; image[49158]=1; image[49159]=1; image[49160]=1; image[49161]=1; image[49162]=1; image[49163]=1; image[49164]=1; image[49165]=1; image[49166]=1; image[49167]=1; image[49168]=1; image[49169]=1; image[49170]=1; image[49171]=1; image[49172]=1; image[49173]=1; image[49174]=1; image[49175]=1; image[49176]=1; image[49177]=1; image[49178]=1; image[49179]=1; image[49180]=1; image[49181]=1; image[49182]=1; image[49183]=1; image[49184]=1; image[49185]=1; image[49186]=1; image[49187]=1; image[49188]=1; image[49189]=1; image[49190]=1; image[49191]=1; image[49192]=1; image[49193]=1; image[49194]=1; image[49195]=1; image[49196]=1; image[49197]=1; image[49198]=1; image[49199]=1; image[49200]=1; image[49201]=1; image[49202]=1; image[49203]=1; image[49204]=1; image[49205]=1; image[49206]=1; image[49207]=1; image[49208]=1; image[49209]=1; image[49210]=1; image[49211]=1; image[49212]=1; image[49213]=1; image[49214]=1; image[49215]=2; image[49216]=1; image[49217]=1; image[49218]=1; image[49219]=1; image[49220]=1; image[49221]=1; image[49222]=1; image[49223]=1; image[49224]=1; image[49225]=2; image[49226]=1; image[49227]=1; image[49228]=2; image[49229]=3; image[49230]=4; image[49231]=5; image[49232]=6; image[49233]=7; image[49234]=6; image[49235]=6; image[49236]=9; image[49237]=10; image[49238]=12; image[49239]=14; image[49240]=15; image[49241]=17; image[49242]=21; image[49243]=23; image[49244]=24; image[49245]=22; image[49246]=16; image[49247]=17; image[49248]=28; image[49249]=35; image[49250]=26; image[49251]=27; image[49252]=33; image[49253]=36; image[49254]=34; image[49255]=35; image[49256]=36; image[49257]=30; image[49258]=20; image[49259]=7; image[49260]=20; image[49261]=14; image[49262]=24; image[49263]=40; image[49264]=52; image[49265]=111; image[49266]=218; image[49267]=208; image[49268]=64; image[49269]=48; image[49270]=57; image[49271]=55; image[49272]=57; image[49273]=75; image[49274]=76; image[49275]=81; image[49276]=86; image[49277]=80; image[49278]=79; image[49279]=82; image[49280]=81; image[49281]=47; image[49282]=21; image[49283]=17; image[49284]=68; image[49285]=122; image[49286]=114; image[49287]=146; image[49288]=165; image[49289]=192; image[49290]=227; image[49291]=158; image[49292]=97; image[49293]=53; image[49294]=21; image[49295]=11; image[49296]=4; image[49297]=1; image[49298]=1; image[49299]=1; image[49300]=1; image[49301]=1; image[49302]=1; image[49303]=1; image[49304]=1; image[49305]=1; image[49306]=1; image[49307]=1; image[49308]=1; image[49309]=1; image[49310]=1; image[49311]=1; image[49312]=0; image[49313]=1; image[49314]=1; image[49315]=1; image[49316]=1; image[49317]=1; image[49318]=1; image[49319]=1; image[49320]=0; image[49321]=1; image[49322]=1; image[49323]=1; image[49324]=1; image[49325]=1; image[49326]=1; image[49327]=1; image[49328]=1; image[49329]=1; image[49330]=1; image[49331]=1; image[49332]=1; image[49333]=1; image[49334]=1; image[49335]=1; image[49336]=1; image[49337]=1; image[49338]=1; image[49339]=1; image[49340]=1; image[49341]=1; image[49342]=1; image[49343]=1; image[49344]=1; image[49345]=1; image[49346]=1; image[49347]=1; image[49348]=1; image[49349]=1; image[49350]=1; image[49351]=1; image[49352]=1; image[49353]=1; image[49354]=1; image[49355]=1; image[49356]=1; image[49357]=1; image[49358]=1; image[49359]=1; image[49360]=1; image[49361]=1; image[49362]=1; image[49363]=1; image[49364]=1; image[49365]=1; image[49366]=1; image[49367]=1; image[49368]=1; image[49369]=1; image[49370]=1; image[49371]=1; image[49372]=1; image[49373]=1; image[49374]=1; image[49375]=1; image[49376]=1; image[49377]=1; image[49378]=1; image[49379]=1; image[49380]=1; image[49381]=1; image[49382]=1; image[49383]=1; image[49384]=1; image[49385]=1; image[49386]=1; image[49387]=1; image[49388]=1; image[49389]=1; image[49390]=1; image[49391]=1; image[49392]=1; image[49393]=1; image[49394]=1; image[49395]=1; image[49396]=1; image[49397]=1; image[49398]=1; image[49399]=1; image[49400]=1; image[49401]=1; image[49402]=1; image[49403]=1; image[49404]=1; image[49405]=1; image[49406]=1; image[49407]=1; image[49408]=1; image[49409]=1; image[49410]=1; image[49411]=1; image[49412]=1; image[49413]=1; image[49414]=1; image[49415]=1; image[49416]=1; image[49417]=1; image[49418]=1; image[49419]=1; image[49420]=1; image[49421]=1; image[49422]=3; image[49423]=3; image[49424]=3; image[49425]=4; image[49426]=4; image[49427]=5; image[49428]=4; image[49429]=4; image[49430]=4; image[49431]=4; image[49432]=5; image[49433]=4; image[49434]=4; image[49435]=6; image[49436]=7; image[49437]=9; image[49438]=12; image[49439]=13; image[49440]=15; image[49441]=18; image[49442]=19; image[49443]=20; image[49444]=16; image[49445]=12; image[49446]=19; image[49447]=31; image[49448]=33; image[49449]=23; image[49450]=27; image[49451]=34; image[49452]=34; image[49453]=32; image[49454]=33; image[49455]=32; image[49456]=29; image[49457]=15; image[49458]=7; image[49459]=28; image[49460]=24; image[49461]=35; image[49462]=42; image[49463]=31; image[49464]=72; image[49465]=165; image[49466]=139; image[49467]=59; image[49468]=49; image[49469]=50; image[49470]=59; image[49471]=66; image[49472]=74; image[49473]=71; image[49474]=74; image[49475]=80; image[49476]=74; image[49477]=75; image[49478]=83; image[49479]=82; image[49480]=40; image[49481]=16; image[49482]=23; image[49483]=82; image[49484]=114; image[49485]=116; image[49486]=150; image[49487]=158; image[49488]=163; image[49489]=173; image[49490]=153; image[49491]=71; image[49492]=31; image[49493]=22; image[49494]=10; image[49495]=3; image[49496]=1; image[49497]=1; image[49498]=1; image[49499]=1; image[49500]=1; image[49501]=1; image[49502]=1; image[49503]=1; image[49504]=1; image[49505]=1; image[49506]=1; image[49507]=1; image[49508]=1; image[49509]=1; image[49510]=1; image[49511]=1; image[49512]=1; image[49513]=1; image[49514]=1; image[49515]=1; image[49516]=1; image[49517]=1; image[49518]=1; image[49519]=1; image[49520]=1; image[49521]=1; image[49522]=1; image[49523]=1; image[49524]=1; image[49525]=1; image[49526]=1; image[49527]=1; image[49528]=1; image[49529]=1; image[49530]=1; image[49531]=1; image[49532]=1; image[49533]=1; image[49534]=1; image[49535]=1; image[49536]=1; image[49537]=1; image[49538]=1; image[49539]=1; image[49540]=1; image[49541]=1; image[49542]=1; image[49543]=1; image[49544]=1; image[49545]=1; image[49546]=1; image[49547]=1; image[49548]=1; image[49549]=1; image[49550]=1; image[49551]=1; image[49552]=1; image[49553]=1; image[49554]=1; image[49555]=1; image[49556]=1; image[49557]=1; image[49558]=1; image[49559]=1; image[49560]=1; image[49561]=1; image[49562]=1; image[49563]=1; image[49564]=1; image[49565]=1; image[49566]=1; image[49567]=1; image[49568]=1; image[49569]=1; image[49570]=1; image[49571]=1; image[49572]=1; image[49573]=1; image[49574]=1; image[49575]=1; image[49576]=1; image[49577]=1; image[49578]=1; image[49579]=1; image[49580]=1; image[49581]=1; image[49582]=1; image[49583]=1; image[49584]=1; image[49585]=1; image[49586]=1; image[49587]=1; image[49588]=1; image[49589]=1; image[49590]=1; image[49591]=1; image[49592]=1; image[49593]=1; image[49594]=1; image[49595]=1; image[49596]=1; image[49597]=1; image[49598]=1; image[49599]=1; image[49600]=1; image[49601]=1; image[49602]=1; image[49603]=1; image[49604]=1; image[49605]=1; image[49606]=1; image[49607]=1; image[49608]=1; image[49609]=1; image[49610]=1; image[49611]=1; image[49612]=1; image[49613]=1; image[49614]=1; image[49615]=1; image[49616]=1; image[49617]=1; image[49618]=1; image[49619]=2; image[49620]=2; image[49621]=3; image[49622]=3; image[49623]=3; image[49624]=4; image[49625]=6; image[49626]=8; image[49627]=8; image[49628]=8; image[49629]=10; image[49630]=12; image[49631]=14; image[49632]=13; image[49633]=13; image[49634]=13; image[49635]=8; image[49636]=6; image[49637]=8; image[49638]=11; image[49639]=13; image[49640]=17; image[49641]=19; image[49642]=20; image[49643]=14; image[49644]=8; image[49645]=20; image[49646]=29; image[49647]=28; image[49648]=21; image[49649]=27; image[49650]=33; image[49651]=34; image[49652]=30; image[49653]=31; image[49654]=28; image[49655]=25; image[49656]=10; image[49657]=8; image[49658]=30; image[49659]=26; image[49660]=38; image[49661]=56; image[49662]=40; image[49663]=87; image[49664]=155; image[49665]=118; image[49666]=58; image[49667]=48; image[49668]=52; image[49669]=56; image[49670]=60; image[49671]=67; image[49672]=69; image[49673]=74; image[49674]=79; image[49675]=76; image[49676]=78; image[49677]=78; image[49678]=72; image[49679]=35; image[49680]=16; image[49681]=30; image[49682]=83; image[49683]=109; image[49684]=126; image[49685]=152; image[49686]=161; image[49687]=182; image[49688]=182; image[49689]=128; image[49690]=61; image[49691]=27; image[49692]=21; image[49693]=8; image[49694]=2; image[49695]=1; image[49696]=1; image[49697]=1; image[49698]=1; image[49699]=1; image[49700]=1; image[49701]=1; image[49702]=1; image[49703]=1; image[49704]=1; image[49705]=1; image[49706]=1; image[49707]=1; image[49708]=1; image[49709]=1; image[49710]=1; image[49711]=1; image[49712]=1; image[49713]=1; image[49714]=1; image[49715]=1; image[49716]=1; image[49717]=1; image[49718]=1; image[49719]=1; image[49720]=1; image[49721]=1; image[49722]=1; image[49723]=1; image[49724]=1; image[49725]=0; image[49726]=1; image[49727]=1; image[49728]=1; image[49729]=1; image[49730]=1; image[49731]=1; image[49732]=1; image[49733]=1; image[49734]=1; image[49735]=1; image[49736]=1; image[49737]=1; image[49738]=1; image[49739]=1; image[49740]=1; image[49741]=1; image[49742]=1; image[49743]=1; image[49744]=1; image[49745]=1; image[49746]=1; image[49747]=1; image[49748]=1; image[49749]=1; image[49750]=1; image[49751]=1; image[49752]=1; image[49753]=1; image[49754]=1; image[49755]=1; image[49756]=1; image[49757]=1; image[49758]=1; image[49759]=1; image[49760]=1; image[49761]=1; image[49762]=1; image[49763]=1; image[49764]=1; image[49765]=1; image[49766]=1; image[49767]=1; image[49768]=1; image[49769]=1; image[49770]=1; image[49771]=1; image[49772]=1; image[49773]=1; image[49774]=1; image[49775]=1; image[49776]=1; image[49777]=1; image[49778]=1; image[49779]=1; image[49780]=1; image[49781]=1; image[49782]=1; image[49783]=1; image[49784]=1; image[49785]=1; image[49786]=1; image[49787]=1; image[49788]=1; image[49789]=1; image[49790]=1; image[49791]=1; image[49792]=1; image[49793]=1; image[49794]=1; image[49795]=1; image[49796]=1; image[49797]=1; image[49798]=1; image[49799]=1; image[49800]=1; image[49801]=1; image[49802]=1; image[49803]=1; image[49804]=1; image[49805]=1; image[49806]=1; image[49807]=1; image[49808]=1; image[49809]=1; image[49810]=1; image[49811]=1; image[49812]=1; image[49813]=1; image[49814]=1; image[49815]=1; image[49816]=1; image[49817]=1; image[49818]=1; image[49819]=2; image[49820]=3; image[49821]=4; image[49822]=4; image[49823]=4; image[49824]=4; image[49825]=6; image[49826]=7; image[49827]=8; image[49828]=10; image[49829]=12; image[49830]=14; image[49831]=18; image[49832]=25; image[49833]=31; image[49834]=29; image[49835]=24; image[49836]=10; image[49837]=5; image[49838]=5; image[49839]=9; image[49840]=10; image[49841]=15; image[49842]=9; image[49843]=4; image[49844]=20; image[49845]=27; image[49846]=24; image[49847]=22; image[49848]=27; image[49849]=33; image[49850]=35; image[49851]=34; image[49852]=35; image[49853]=26; image[49854]=21; image[49855]=7; image[49856]=11; image[49857]=36; image[49858]=23; image[49859]=40; image[49860]=55; image[49861]=43; image[49862]=117; image[49863]=157; image[49864]=95; image[49865]=53; image[49866]=46; image[49867]=46; image[49868]=54; image[49869]=63; image[49870]=65; image[49871]=66; image[49872]=74; image[49873]=79; image[49874]=75; image[49875]=77; image[49876]=78; image[49877]=62; image[49878]=28; image[49879]=17; image[49880]=31; image[49881]=81; image[49882]=115; image[49883]=133; image[49884]=151; image[49885]=167; image[49886]=206; image[49887]=220; image[49888]=118; image[49889]=52; image[49890]=30; image[49891]=17; image[49892]=7; image[49893]=1; image[49894]=1; image[49895]=1; image[49896]=1; image[49897]=1; image[49898]=1; image[49899]=1; image[49900]=1; image[49901]=1; image[49902]=1; image[49903]=1; image[49904]=1; image[49905]=1; image[49906]=1; image[49907]=1; image[49908]=1; image[49909]=1; image[49910]=1; image[49911]=1; image[49912]=1; image[49913]=1; image[49914]=1; image[49915]=1; image[49916]=1; image[49917]=1; image[49918]=1; image[49919]=1; image[49920]=0; image[49921]=1; image[49922]=1; image[49923]=1; image[49924]=1; image[49925]=1; image[49926]=1; image[49927]=1; image[49928]=1; image[49929]=1; image[49930]=0; image[49931]=1; image[49932]=1; image[49933]=1; image[49934]=1; image[49935]=1; image[49936]=1; image[49937]=1; image[49938]=1; image[49939]=1; image[49940]=1; image[49941]=1; image[49942]=1; image[49943]=1; image[49944]=1; image[49945]=1; image[49946]=1; image[49947]=1; image[49948]=1; image[49949]=1; image[49950]=1; image[49951]=1; image[49952]=1; image[49953]=1; image[49954]=1; image[49955]=1; image[49956]=1; image[49957]=1; image[49958]=1; image[49959]=1; image[49960]=1; image[49961]=1; image[49962]=1; image[49963]=1; image[49964]=1; image[49965]=1; image[49966]=1; image[49967]=1; image[49968]=1; image[49969]=1; image[49970]=1; image[49971]=1; image[49972]=1; image[49973]=1; image[49974]=1; image[49975]=1; image[49976]=1; image[49977]=1; image[49978]=1; image[49979]=1; image[49980]=1; image[49981]=1; image[49982]=1; image[49983]=1; image[49984]=1; image[49985]=1; image[49986]=1; image[49987]=1; image[49988]=1; image[49989]=1; image[49990]=1; image[49991]=1; image[49992]=1; image[49993]=1; image[49994]=1; image[49995]=1; image[49996]=1; image[49997]=1; image[49998]=1; image[49999]=1; image[50000]=1; image[50001]=1; image[50002]=1; image[50003]=1; image[50004]=1; image[50005]=1; image[50006]=1; image[50007]=1; image[50008]=1; image[50009]=1; image[50010]=1; image[50011]=1; image[50012]=1; image[50013]=1; image[50014]=1; image[50015]=1; image[50016]=1; image[50017]=1; image[50018]=2; image[50019]=3; image[50020]=3; image[50021]=4; image[50022]=4; image[50023]=4; image[50024]=6; image[50025]=7; image[50026]=8; image[50027]=11; image[50028]=12; image[50029]=11; image[50030]=15; image[50031]=20; image[50032]=22; image[50033]=26; image[50034]=33; image[50035]=35; image[50036]=19; image[50037]=7; image[50038]=4; image[50039]=4; image[50040]=5; image[50041]=4; image[50042]=4; image[50043]=24; image[50044]=30; image[50045]=23; image[50046]=23; image[50047]=31; image[50048]=36; image[50049]=31; image[50050]=31; image[50051]=37; image[50052]=29; image[50053]=18; image[50054]=5; image[50055]=9; image[50056]=35; image[50057]=25; image[50058]=36; image[50059]=49; image[50060]=60; image[50061]=165; image[50062]=165; image[50063]=77; image[50064]=42; image[50065]=45; image[50066]=46; image[50067]=48; image[50068]=57; image[50069]=62; image[50070]=69; image[50071]=77; image[50072]=82; image[50073]=76; image[50074]=75; image[50075]=78; image[50076]=58; image[50077]=22; image[50078]=17; image[50079]=38; image[50080]=91; image[50081]=112; image[50082]=127; image[50083]=158; image[50084]=186; image[50085]=177; image[50086]=162; image[50087]=105; image[50088]=43; image[50089]=23; image[50090]=9; image[50091]=3; image[50092]=1; image[50093]=1; image[50094]=1; image[50095]=1; image[50096]=1; image[50097]=1; image[50098]=1; image[50099]=1; image[50100]=1; image[50101]=1; image[50102]=1; image[50103]=1; image[50104]=1; image[50105]=1; image[50106]=1; image[50107]=1; image[50108]=1; image[50109]=1; image[50110]=0; image[50111]=1; image[50112]=1; image[50113]=1; image[50114]=1; image[50115]=1; image[50116]=1; image[50117]=1; image[50118]=1; image[50119]=1; image[50120]=1; image[50121]=1; image[50122]=1; image[50123]=1; image[50124]=1; image[50125]=1; image[50126]=1; image[50127]=1; image[50128]=1; image[50129]=1; image[50130]=1; image[50131]=1; image[50132]=1; image[50133]=1; image[50134]=1; image[50135]=1; image[50136]=1; image[50137]=1; image[50138]=1; image[50139]=1; image[50140]=1; image[50141]=1; image[50142]=1; image[50143]=1; image[50144]=1; image[50145]=1; image[50146]=1; image[50147]=1; image[50148]=1; image[50149]=1; image[50150]=1; image[50151]=1; image[50152]=1; image[50153]=1; image[50154]=1; image[50155]=1; image[50156]=1; image[50157]=1; image[50158]=1; image[50159]=1; image[50160]=1; image[50161]=1; image[50162]=1; image[50163]=1; image[50164]=1; image[50165]=1; image[50166]=1; image[50167]=1; image[50168]=1; image[50169]=1; image[50170]=1; image[50171]=1; image[50172]=1; image[50173]=1; image[50174]=1; image[50175]=1; image[50176]=1; image[50177]=1; image[50178]=1; image[50179]=1; image[50180]=1; image[50181]=1; image[50182]=1; image[50183]=1; image[50184]=1; image[50185]=1; image[50186]=1; image[50187]=1; image[50188]=1; image[50189]=1; image[50190]=1; image[50191]=1; image[50192]=1; image[50193]=1; image[50194]=1; image[50195]=1; image[50196]=1; image[50197]=1; image[50198]=1; image[50199]=1; image[50200]=1; image[50201]=1; image[50202]=1; image[50203]=1; image[50204]=1; image[50205]=1; image[50206]=1; image[50207]=1; image[50208]=1; image[50209]=1; image[50210]=1; image[50211]=1; image[50212]=1; image[50213]=1; image[50214]=1; image[50215]=1; image[50216]=1; image[50217]=1; image[50218]=1; image[50219]=2; image[50220]=2; image[50221]=3; image[50222]=4; image[50223]=6; image[50224]=7; image[50225]=7; image[50226]=10; image[50227]=12; image[50228]=13; image[50229]=16; image[50230]=18; image[50231]=20; image[50232]=24; image[50233]=25; image[50234]=26; image[50235]=28; image[50236]=20; image[50237]=8; image[50238]=6; image[50239]=4; image[50240]=3; image[50241]=7; image[50242]=28; image[50243]=30; image[50244]=22; image[50245]=21; image[50246]=28; image[50247]=33; image[50248]=29; image[50249]=29; image[50250]=34; image[50251]=28; image[50252]=17; image[50253]=5; image[50254]=4; image[50255]=27; image[50256]=24; image[50257]=19; image[50258]=39; image[50259]=79; image[50260]=183; image[50261]=142; image[50262]=56; image[50263]=40; image[50264]=44; image[50265]=48; image[50266]=49; image[50267]=53; image[50268]=60; image[50269]=66; image[50270]=75; image[50271]=83; image[50272]=77; image[50273]=72; image[50274]=73; image[50275]=49; image[50276]=18; image[50277]=21; image[50278]=46; image[50279]=96; image[50280]=109; image[50281]=127; image[50282]=151; image[50283]=174; image[50284]=151; image[50285]=140; image[50286]=94; image[50287]=27; image[50288]=16; image[50289]=8; image[50290]=3; image[50291]=1; image[50292]=1; image[50293]=1; image[50294]=1; image[50295]=1; image[50296]=1; image[50297]=0; image[50298]=1; image[50299]=1; image[50300]=1; image[50301]=1; image[50302]=1; image[50303]=1; image[50304]=1; image[50305]=1; image[50306]=1; image[50307]=1; image[50308]=1; image[50309]=1; image[50310]=1; image[50311]=1; image[50312]=1; image[50313]=1; image[50314]=1; image[50315]=1; image[50316]=0; image[50317]=1; image[50318]=1; image[50319]=1; image[50320]=1; image[50321]=1; image[50322]=1; image[50323]=1; image[50324]=1; image[50325]=1; image[50326]=1; image[50327]=1; image[50328]=1; image[50329]=1; image[50330]=1; image[50331]=1; image[50332]=1; image[50333]=1; image[50334]=1; image[50335]=1; image[50336]=1; image[50337]=1; image[50338]=1; image[50339]=1; image[50340]=1; image[50341]=1; image[50342]=1; image[50343]=1; image[50344]=1; image[50345]=1; image[50346]=1; image[50347]=1; image[50348]=1; image[50349]=1; image[50350]=1; image[50351]=1; image[50352]=1; image[50353]=1; image[50354]=1; image[50355]=1; image[50356]=1; image[50357]=1; image[50358]=1; image[50359]=1; image[50360]=1; image[50361]=1; image[50362]=1; image[50363]=1; image[50364]=1; image[50365]=1; image[50366]=1; image[50367]=1; image[50368]=1; image[50369]=1; image[50370]=1; image[50371]=1; image[50372]=1; image[50373]=1; image[50374]=1; image[50375]=1; image[50376]=1; image[50377]=1; image[50378]=1; image[50379]=1; image[50380]=1; image[50381]=1; image[50382]=1; image[50383]=1; image[50384]=1; image[50385]=1; image[50386]=1; image[50387]=1; image[50388]=1; image[50389]=1; image[50390]=1; image[50391]=1; image[50392]=1; image[50393]=1; image[50394]=1; image[50395]=1; image[50396]=1; image[50397]=1; image[50398]=1; image[50399]=1; image[50400]=1; image[50401]=1; image[50402]=1; image[50403]=1; image[50404]=1; image[50405]=1; image[50406]=1; image[50407]=1; image[50408]=1; image[50409]=1; image[50410]=1; image[50411]=1; image[50412]=1; image[50413]=1; image[50414]=2; image[50415]=3; image[50416]=3; image[50417]=2; image[50418]=2; image[50419]=2; image[50420]=2; image[50421]=2; image[50422]=3; image[50423]=5; image[50424]=7; image[50425]=11; image[50426]=13; image[50427]=14; image[50428]=17; image[50429]=19; image[50430]=20; image[50431]=26; image[50432]=28; image[50433]=17; image[50434]=20; image[50435]=22; image[50436]=15; image[50437]=12; image[50438]=7; image[50439]=4; image[50440]=9; image[50441]=32; image[50442]=27; image[50443]=19; image[50444]=25; image[50445]=32; image[50446]=31; image[50447]=27; image[50448]=31; image[50449]=35; image[50450]=27; image[50451]=15; image[50452]=5; image[50453]=5; image[50454]=31; image[50455]=34; image[50456]=15; image[50457]=30; image[50458]=92; image[50459]=173; image[50460]=100; image[50461]=39; image[50462]=42; image[50463]=42; image[50464]=45; image[50465]=51; image[50466]=56; image[50467]=63; image[50468]=66; image[50469]=73; image[50470]=81; image[50471]=78; image[50472]=69; image[50473]=63; image[50474]=37; image[50475]=18; image[50476]=24; image[50477]=54; image[50478]=99; image[50479]=119; image[50480]=132; image[50481]=155; image[50482]=167; image[50483]=142; image[50484]=103; image[50485]=58; image[50486]=24; image[50487]=13; image[50488]=5; image[50489]=2; image[50490]=1; image[50491]=1; image[50492]=1; image[50493]=1; image[50494]=1; image[50495]=1; image[50496]=1; image[50497]=1; image[50498]=1; image[50499]=1; image[50500]=1; image[50501]=1; image[50502]=1; image[50503]=1; image[50504]=1; image[50505]=1; image[50506]=1; image[50507]=1; image[50508]=1; image[50509]=0; image[50510]=1; image[50511]=1; image[50512]=1; image[50513]=1; image[50514]=1; image[50515]=1; image[50516]=1; image[50517]=1; image[50518]=1; image[50519]=1; image[50520]=1; image[50521]=1; image[50522]=1; image[50523]=1; image[50524]=1; image[50525]=1; image[50526]=1; image[50527]=1; image[50528]=1; image[50529]=1; image[50530]=1; image[50531]=1; image[50532]=1; image[50533]=1; image[50534]=1; image[50535]=1; image[50536]=1; image[50537]=1; image[50538]=1; image[50539]=0; image[50540]=1; image[50541]=1; image[50542]=1; image[50543]=1; image[50544]=1; image[50545]=1; image[50546]=1; image[50547]=1; image[50548]=1; image[50549]=1; image[50550]=1; image[50551]=1; image[50552]=1; image[50553]=1; image[50554]=1; image[50555]=1; image[50556]=1; image[50557]=1; image[50558]=1; image[50559]=1; image[50560]=1; image[50561]=1; image[50562]=1; image[50563]=1; image[50564]=1; image[50565]=1; image[50566]=1; image[50567]=1; image[50568]=1; image[50569]=1; image[50570]=1; image[50571]=1; image[50572]=1; image[50573]=1; image[50574]=1; image[50575]=1; image[50576]=1; image[50577]=1; image[50578]=1; image[50579]=1; image[50580]=1; image[50581]=1; image[50582]=1; image[50583]=1; image[50584]=1; image[50585]=1; image[50586]=1; image[50587]=1; image[50588]=1; image[50589]=1; image[50590]=1; image[50591]=1; image[50592]=1; image[50593]=1; image[50594]=2; image[50595]=1; image[50596]=1; image[50597]=1; image[50598]=1; image[50599]=1; image[50600]=1; image[50601]=1; image[50602]=1; image[50603]=1; image[50604]=1; image[50605]=1; image[50606]=1; image[50607]=1; image[50608]=1; image[50609]=1; image[50610]=1; image[50611]=1; image[50612]=1; image[50613]=2; image[50614]=3; image[50615]=4; image[50616]=4; image[50617]=4; image[50618]=6; image[50619]=5; image[50620]=5; image[50621]=4; image[50622]=3; image[50623]=3; image[50624]=6; image[50625]=9; image[50626]=12; image[50627]=20; image[50628]=24; image[50629]=25; image[50630]=30; image[50631]=28; image[50632]=21; image[50633]=25; image[50634]=24; image[50635]=13; image[50636]=11; image[50637]=8; image[50638]=5; image[50639]=12; image[50640]=33; image[50641]=26; image[50642]=15; image[50643]=27; image[50644]=36; image[50645]=33; image[50646]=27; image[50647]=33; image[50648]=34; image[50649]=21; image[50650]=11; image[50651]=4; image[50652]=6; image[50653]=32; image[50654]=42; image[50655]=18; image[50656]=14; image[50657]=70; image[50658]=129; image[50659]=64; image[50660]=35; image[50661]=41; image[50662]=43; image[50663]=48; image[50664]=50; image[50665]=58; image[50666]=63; image[50667]=64; image[50668]=74; image[50669]=74; image[50670]=78; image[50671]=76; image[50672]=65; image[50673]=33; image[50674]=19; image[50675]=23; image[50676]=54; image[50677]=94; image[50678]=109; image[50679]=121; image[50680]=145; image[50681]=145; image[50682]=135; image[50683]=101; image[50684]=42; image[50685]=22; image[50686]=12; image[50687]=4; image[50688]=2; image[50689]=1; image[50690]=1; image[50691]=1; image[50692]=1; image[50693]=1; image[50694]=1; image[50695]=1; image[50696]=1; image[50697]=1; image[50698]=1; image[50699]=1; image[50700]=1; image[50701]=1; image[50702]=1; image[50703]=1; image[50704]=1; image[50705]=1; image[50706]=1; image[50707]=1; image[50708]=1; image[50709]=0; image[50710]=1; image[50711]=1; image[50712]=1; image[50713]=1; image[50714]=1; image[50715]=1; image[50716]=1; image[50717]=1; image[50718]=1; image[50719]=1; image[50720]=1; image[50721]=1; image[50722]=1; image[50723]=1; image[50724]=1; image[50725]=1; image[50726]=1; image[50727]=1; image[50728]=1; image[50729]=1; image[50730]=1; image[50731]=1; image[50732]=1; image[50733]=1; image[50734]=1; image[50735]=1; image[50736]=1; image[50737]=1; image[50738]=1; image[50739]=1; image[50740]=1; image[50741]=1; image[50742]=1; image[50743]=1; image[50744]=1; image[50745]=1; image[50746]=1; image[50747]=1; image[50748]=1; image[50749]=1; image[50750]=1; image[50751]=1; image[50752]=1; image[50753]=1; image[50754]=1; image[50755]=1; image[50756]=1; image[50757]=1; image[50758]=1; image[50759]=1; image[50760]=1; image[50761]=1; image[50762]=1; image[50763]=1; image[50764]=1; image[50765]=1; image[50766]=1; image[50767]=1; image[50768]=1; image[50769]=1; image[50770]=1; image[50771]=1; image[50772]=1; image[50773]=1; image[50774]=1; image[50775]=1; image[50776]=1; image[50777]=1; image[50778]=1; image[50779]=1; image[50780]=1; image[50781]=1; image[50782]=1; image[50783]=1; image[50784]=1; image[50785]=1; image[50786]=1; image[50787]=1; image[50788]=1; image[50789]=1; image[50790]=1; image[50791]=1; image[50792]=1; image[50793]=1; image[50794]=1; image[50795]=1; image[50796]=1; image[50797]=1; image[50798]=1; image[50799]=1; image[50800]=1; image[50801]=1; image[50802]=1; image[50803]=1; image[50804]=1; image[50805]=1; image[50806]=1; image[50807]=1; image[50808]=1; image[50809]=1; image[50810]=2; image[50811]=2; image[50812]=3; image[50813]=3; image[50814]=4; image[50815]=4; image[50816]=4; image[50817]=5; image[50818]=6; image[50819]=7; image[50820]=9; image[50821]=7; image[50822]=6; image[50823]=4; image[50824]=3; image[50825]=3; image[50826]=7; image[50827]=14; image[50828]=22; image[50829]=31; image[50830]=28; image[50831]=20; image[50832]=18; image[50833]=14; image[50834]=5; image[50835]=4; image[50836]=3; image[50837]=6; image[50838]=17; image[50839]=35; image[50840]=26; image[50841]=15; image[50842]=28; image[50843]=34; image[50844]=30; image[50845]=26; image[50846]=32; image[50847]=32; image[50848]=18; image[50849]=8; image[50850]=4; image[50851]=8; image[50852]=37; image[50853]=47; image[50854]=28; image[50855]=12; image[50856]=46; image[50857]=77; image[50858]=39; image[50859]=36; image[50860]=39; image[50861]=41; image[50862]=45; image[50863]=48; image[50864]=56; image[50865]=65; image[50866]=64; image[50867]=69; image[50868]=69; image[50869]=72; image[50870]=72; image[50871]=57; image[50872]=29; image[50873]=23; image[50874]=28; image[50875]=60; image[50876]=98; image[50877]=114; image[50878]=118; image[50879]=127; image[50880]=132; image[50881]=108; image[50882]=80; image[50883]=34; image[50884]=16; image[50885]=9; image[50886]=3; image[50887]=2; image[50888]=1; image[50889]=1; image[50890]=1; image[50891]=1; image[50892]=1; image[50893]=1; image[50894]=1; image[50895]=1; image[50896]=0; image[50897]=1; image[50898]=1; image[50899]=1; image[50900]=1; image[50901]=1; image[50902]=1; image[50903]=1; image[50904]=1; image[50905]=1; image[50906]=1; image[50907]=1; image[50908]=1; image[50909]=1; image[50910]=1; image[50911]=1; image[50912]=1; image[50913]=1; image[50914]=1; image[50915]=1; image[50916]=1; image[50917]=1; image[50918]=1; image[50919]=1; image[50920]=0; image[50921]=1; image[50922]=1; image[50923]=1; image[50924]=1; image[50925]=1; image[50926]=0; image[50927]=1; image[50928]=1; image[50929]=1; image[50930]=1; image[50931]=1; image[50932]=1; image[50933]=1; image[50934]=1; image[50935]=1; image[50936]=1; image[50937]=1; image[50938]=1; image[50939]=1; image[50940]=1; image[50941]=1; image[50942]=1; image[50943]=1; image[50944]=1; image[50945]=1; image[50946]=1; image[50947]=1; image[50948]=1; image[50949]=1; image[50950]=1; image[50951]=1; image[50952]=1; image[50953]=1; image[50954]=1; image[50955]=1; image[50956]=1; image[50957]=1; image[50958]=1; image[50959]=1; image[50960]=1; image[50961]=1; image[50962]=1; image[50963]=1; image[50964]=1; image[50965]=1; image[50966]=1; image[50967]=1; image[50968]=1; image[50969]=1; image[50970]=1; image[50971]=1; image[50972]=1; image[50973]=1; image[50974]=1; image[50975]=1; image[50976]=1; image[50977]=1; image[50978]=1; image[50979]=1; image[50980]=1; image[50981]=1; image[50982]=1; image[50983]=1; image[50984]=1; image[50985]=1; image[50986]=1; image[50987]=1; image[50988]=1; image[50989]=1; image[50990]=1; image[50991]=1; image[50992]=1; image[50993]=1; image[50994]=1; image[50995]=1; image[50996]=1; image[50997]=1; image[50998]=1; image[50999]=1; image[51000]=1; image[51001]=1; image[51002]=1; image[51003]=1; image[51004]=1; image[51005]=1; image[51006]=1; image[51007]=1; image[51008]=1; image[51009]=2; image[51010]=2; image[51011]=2; image[51012]=3; image[51013]=4; image[51014]=4; image[51015]=4; image[51016]=4; image[51017]=5; image[51018]=6; image[51019]=7; image[51020]=8; image[51021]=11; image[51022]=11; image[51023]=10; image[51024]=10; image[51025]=8; image[51026]=7; image[51027]=5; image[51028]=5; image[51029]=5; image[51030]=4; image[51031]=3; image[51032]=2; image[51033]=3; image[51034]=2; image[51035]=0; image[51036]=9; image[51037]=23; image[51038]=30; image[51039]=23; image[51040]=17; image[51041]=31; image[51042]=34; image[51043]=27; image[51044]=29; image[51045]=35; image[51046]=28; image[51047]=18; image[51048]=8; image[51049]=4; image[51050]=12; image[51051]=41; image[51052]=39; image[51053]=27; image[51054]=16; image[51055]=40; image[51056]=49; image[51057]=30; image[51058]=39; image[51059]=39; image[51060]=44; image[51061]=52; image[51062]=53; image[51063]=57; image[51064]=68; image[51065]=65; image[51066]=64; image[51067]=69; image[51068]=72; image[51069]=69; image[51070]=51; image[51071]=26; image[51072]=20; image[51073]=35; image[51074]=74; image[51075]=95; image[51076]=110; image[51077]=119; image[51078]=108; image[51079]=119; image[51080]=135; image[51081]=74; image[51082]=23; image[51083]=18; image[51084]=10; image[51085]=3; image[51086]=1; image[51087]=1; image[51088]=1; image[51089]=1; image[51090]=1; image[51091]=1; image[51092]=1; image[51093]=1; image[51094]=1; image[51095]=1; image[51096]=1; image[51097]=1; image[51098]=1; image[51099]=1; image[51100]=1; image[51101]=1; image[51102]=1; image[51103]=1; image[51104]=1; image[51105]=1; image[51106]=1; image[51107]=1; image[51108]=1; image[51109]=1; image[51110]=1; image[51111]=1; image[51112]=1; image[51113]=1; image[51114]=1; image[51115]=1; image[51116]=1; image[51117]=1; image[51118]=1; image[51119]=1; image[51120]=1; image[51121]=1; image[51122]=1; image[51123]=1; image[51124]=1; image[51125]=1; image[51126]=1; image[51127]=1; image[51128]=1; image[51129]=1; image[51130]=1; image[51131]=1; image[51132]=1; image[51133]=1; image[51134]=1; image[51135]=0; image[51136]=1; image[51137]=1; image[51138]=1; image[51139]=1; image[51140]=1; image[51141]=1; image[51142]=1; image[51143]=1; image[51144]=1; image[51145]=1; image[51146]=1; image[51147]=1; image[51148]=1; image[51149]=1; image[51150]=1; image[51151]=1; image[51152]=1; image[51153]=1; image[51154]=1; image[51155]=1; image[51156]=1; image[51157]=1; image[51158]=1; image[51159]=1; image[51160]=1; image[51161]=1; image[51162]=1; image[51163]=1; image[51164]=1; image[51165]=1; image[51166]=1; image[51167]=1; image[51168]=1; image[51169]=1; image[51170]=1; image[51171]=1; image[51172]=1; image[51173]=1; image[51174]=1; image[51175]=1; image[51176]=1; image[51177]=1; image[51178]=1; image[51179]=1; image[51180]=1; image[51181]=1; image[51182]=1; image[51183]=1; image[51184]=1; image[51185]=1; image[51186]=1; image[51187]=1; image[51188]=1; image[51189]=1; image[51190]=1; image[51191]=1; image[51192]=1; image[51193]=1; image[51194]=1; image[51195]=1; image[51196]=1; image[51197]=1; image[51198]=1; image[51199]=1; image[51200]=1; image[51201]=1; image[51202]=1; image[51203]=1; image[51204]=1; image[51205]=1; image[51206]=1; image[51207]=1; image[51208]=1; image[51209]=2; image[51210]=3; image[51211]=3; image[51212]=3; image[51213]=4; image[51214]=4; image[51215]=4; image[51216]=5; image[51217]=6; image[51218]=7; image[51219]=8; image[51220]=9; image[51221]=10; image[51222]=13; image[51223]=14; image[51224]=16; image[51225]=16; image[51226]=15; image[51227]=16; image[51228]=16; image[51229]=14; image[51230]=13; image[51231]=10; image[51232]=6; image[51233]=5; image[51234]=2; image[51235]=13; image[51236]=24; image[51237]=27; image[51238]=21; image[51239]=17; image[51240]=31; image[51241]=34; image[51242]=28; image[51243]=30; image[51244]=33; image[51245]=24; image[51246]=15; image[51247]=7; image[51248]=4; image[51249]=18; image[51250]=48; image[51251]=41; image[51252]=24; image[51253]=14; image[51254]=28; image[51255]=36; image[51256]=37; image[51257]=45; image[51258]=43; image[51259]=47; image[51260]=50; image[51261]=52; image[51262]=57; image[51263]=65; image[51264]=64; image[51265]=62; image[51266]=70; image[51267]=71; image[51268]=69; image[51269]=47; image[51270]=22; image[51271]=18; image[51272]=36; image[51273]=77; image[51274]=93; image[51275]=106; image[51276]=114; image[51277]=102; image[51278]=93; image[51279]=111; image[51280]=98; image[51281]=39; image[51282]=14; image[51283]=7; image[51284]=2; image[51285]=1; image[51286]=1; image[51287]=1; image[51288]=1; image[51289]=1; image[51290]=1; image[51291]=0; image[51292]=1; image[51293]=1; image[51294]=1; image[51295]=1; image[51296]=1; image[51297]=1; image[51298]=1; image[51299]=1; image[51300]=1; image[51301]=1; image[51302]=1; image[51303]=1; image[51304]=1; image[51305]=1; image[51306]=1; image[51307]=1; image[51308]=1; image[51309]=1; image[51310]=1; image[51311]=1; image[51312]=1; image[51313]=1; image[51314]=1; image[51315]=1; image[51316]=1; image[51317]=1; image[51318]=1; image[51319]=1; image[51320]=1; image[51321]=1; image[51322]=1; image[51323]=1; image[51324]=1; image[51325]=1; image[51326]=1; image[51327]=1; image[51328]=1; image[51329]=1; image[51330]=1; image[51331]=1; image[51332]=0; image[51333]=1; image[51334]=1; image[51335]=1; image[51336]=1; image[51337]=1; image[51338]=1; image[51339]=1; image[51340]=1; image[51341]=1; image[51342]=1; image[51343]=1; image[51344]=1; image[51345]=1; image[51346]=1; image[51347]=1; image[51348]=1; image[51349]=1; image[51350]=1; image[51351]=1; image[51352]=1; image[51353]=1; image[51354]=1; image[51355]=1; image[51356]=1; image[51357]=1; image[51358]=1; image[51359]=1; image[51360]=1; image[51361]=1; image[51362]=1; image[51363]=1; image[51364]=1; image[51365]=1; image[51366]=1; image[51367]=1; image[51368]=1; image[51369]=1; image[51370]=1; image[51371]=1; image[51372]=1; image[51373]=1; image[51374]=1; image[51375]=1; image[51376]=1; image[51377]=1; image[51378]=1; image[51379]=1; image[51380]=1; image[51381]=1; image[51382]=1; image[51383]=1; image[51384]=1; image[51385]=1; image[51386]=1; image[51387]=1; image[51388]=1; image[51389]=1; image[51390]=1; image[51391]=1; image[51392]=1; image[51393]=1; image[51394]=1; image[51395]=1; image[51396]=1; image[51397]=1; image[51398]=1; image[51399]=1; image[51400]=1; image[51401]=1; image[51402]=1; image[51403]=1; image[51404]=3; image[51405]=3; image[51406]=2; image[51407]=1; image[51408]=2; image[51409]=3; image[51410]=3; image[51411]=3; image[51412]=4; image[51413]=4; image[51414]=4; image[51415]=4; image[51416]=5; image[51417]=8; image[51418]=8; image[51419]=8; image[51420]=10; image[51421]=12; image[51422]=12; image[51423]=10; image[51424]=12; image[51425]=15; image[51426]=18; image[51427]=21; image[51428]=19; image[51429]=21; image[51430]=21; image[51431]=18; image[51432]=11; image[51433]=4; image[51434]=19; image[51435]=25; image[51436]=24; image[51437]=18; image[51438]=16; image[51439]=32; image[51440]=32; image[51441]=24; image[51442]=30; image[51443]=27; image[51444]=20; image[51445]=12; image[51446]=4; image[51447]=5; image[51448]=25; image[51449]=46; image[51450]=32; image[51451]=17; image[51452]=13; image[51453]=19; image[51454]=32; image[51455]=43; image[51456]=43; image[51457]=42; image[51458]=46; image[51459]=51; image[51460]=53; image[51461]=56; image[51462]=58; image[51463]=53; image[51464]=52; image[51465]=70; image[51466]=68; image[51467]=58; image[51468]=38; image[51469]=18; image[51470]=22; image[51471]=37; image[51472]=66; image[51473]=88; image[51474]=101; image[51475]=109; image[51476]=105; image[51477]=93; image[51478]=81; image[51479]=65; image[51480]=32; image[51481]=12; image[51482]=5; image[51483]=2; image[51484]=1; image[51485]=1; image[51486]=1; image[51487]=1; image[51488]=1; image[51489]=1; image[51490]=1; image[51491]=1; image[51492]=1; image[51493]=0; image[51494]=0; image[51495]=1; image[51496]=1; image[51497]=1; image[51498]=1; image[51499]=1; image[51500]=1; image[51501]=1; image[51502]=1; image[51503]=1; image[51504]=1; image[51505]=1; image[51506]=1; image[51507]=0; image[51508]=1; image[51509]=1; image[51510]=0; image[51511]=1; image[51512]=1; image[51513]=0; image[51514]=1; image[51515]=1; image[51516]=1; image[51517]=1; image[51518]=0; image[51519]=1; image[51520]=1; image[51521]=1; image[51522]=1; image[51523]=1; image[51524]=1; image[51525]=0; image[51526]=1; image[51527]=1; image[51528]=0; image[51529]=0; image[51530]=1; image[51531]=0; image[51532]=1; image[51533]=1; image[51534]=0; image[51535]=1; image[51536]=1; image[51537]=1; image[51538]=1; image[51539]=0; image[51540]=0; image[51541]=1; image[51542]=1; image[51543]=1; image[51544]=1; image[51545]=1; image[51546]=1; image[51547]=1; image[51548]=1; image[51549]=1; image[51550]=1; image[51551]=1; image[51552]=1; image[51553]=1; image[51554]=1; image[51555]=1; image[51556]=1; image[51557]=1; image[51558]=1; image[51559]=1; image[51560]=1; image[51561]=1; image[51562]=1; image[51563]=1; image[51564]=1; image[51565]=1; image[51566]=1; image[51567]=1; image[51568]=1; image[51569]=1; image[51570]=1; image[51571]=1; image[51572]=1; image[51573]=1; image[51574]=1; image[51575]=1; image[51576]=1; image[51577]=1; image[51578]=1; image[51579]=1; image[51580]=1; image[51581]=1; image[51582]=1; image[51583]=1; image[51584]=1; image[51585]=1; image[51586]=1; image[51587]=1; image[51588]=1; image[51589]=1; image[51590]=1; image[51591]=1; image[51592]=1; image[51593]=1; image[51594]=1; image[51595]=1; image[51596]=1; image[51597]=1; image[51598]=1; image[51599]=1; image[51600]=1; image[51601]=1; image[51602]=2; image[51603]=2; image[51604]=3; image[51605]=2; image[51606]=1; image[51607]=2; image[51608]=3; image[51609]=3; image[51610]=3; image[51611]=3; image[51612]=4; image[51613]=4; image[51614]=4; image[51615]=4; image[51616]=6; image[51617]=8; image[51618]=8; image[51619]=8; image[51620]=9; image[51621]=12; image[51622]=13; image[51623]=14; image[51624]=16; image[51625]=14; image[51626]=13; image[51627]=14; image[51628]=16; image[51629]=17; image[51630]=13; image[51631]=7; image[51632]=7; image[51633]=21; image[51634]=23; image[51635]=23; image[51636]=17; image[51637]=17; image[51638]=27; image[51639]=26; image[51640]=24; image[51641]=29; image[51642]=24; image[51643]=16; image[51644]=9; image[51645]=4; image[51646]=5; image[51647]=22; image[51648]=42; image[51649]=34; image[51650]=24; image[51651]=19; image[51652]=28; image[51653]=40; image[51654]=46; image[51655]=43; image[51656]=41; image[51657]=41; image[51658]=48; image[51659]=49; image[51660]=51; image[51661]=48; image[51662]=46; image[51663]=45; image[51664]=56; image[51665]=57; image[51666]=49; image[51667]=32; image[51668]=17; image[51669]=23; image[51670]=42; image[51671]=63; image[51672]=73; image[51673]=89; image[51674]=106; image[51675]=101; image[51676]=70; image[51677]=59; image[51678]=47; image[51679]=16; image[51680]=8; image[51681]=4; image[51682]=1; image[51683]=1; image[51684]=1; image[51685]=1; image[51686]=1; image[51687]=1; image[51688]=1; image[51689]=1; image[51690]=1; image[51691]=1; image[51692]=1; image[51693]=1; image[51694]=1; image[51695]=1; image[51696]=1; image[51697]=1; image[51698]=1; image[51699]=1; image[51700]=1; image[51701]=1; image[51702]=1; image[51703]=1; image[51704]=1; image[51705]=0; image[51706]=1; image[51707]=1; image[51708]=1; image[51709]=1; image[51710]=1; image[51711]=1; image[51712]=0; image[51713]=1; image[51714]=1; image[51715]=1; image[51716]=1; image[51717]=1; image[51718]=1; image[51719]=1; image[51720]=1; image[51721]=1; image[51722]=1; image[51723]=1; image[51724]=1; image[51725]=1; image[51726]=1; image[51727]=1; image[51728]=0; image[51729]=0; image[51730]=1; image[51731]=1; image[51732]=1; image[51733]=1; image[51734]=1; image[51735]=1; image[51736]=1; image[51737]=1; image[51738]=0; image[51739]=1; image[51740]=1; image[51741]=1; image[51742]=1; image[51743]=1; image[51744]=1; image[51745]=1; image[51746]=1; image[51747]=1; image[51748]=1; image[51749]=1; image[51750]=1; image[51751]=1; image[51752]=1; image[51753]=1; image[51754]=1; image[51755]=1; image[51756]=1; image[51757]=1; image[51758]=1; image[51759]=1; image[51760]=1; image[51761]=1; image[51762]=1; image[51763]=1; image[51764]=1; image[51765]=1; image[51766]=1; image[51767]=1; image[51768]=1; image[51769]=1; image[51770]=1; image[51771]=1; image[51772]=1; image[51773]=1; image[51774]=1; image[51775]=1; image[51776]=1; image[51777]=1; image[51778]=1; image[51779]=1; image[51780]=1; image[51781]=1; image[51782]=1; image[51783]=1; image[51784]=1; image[51785]=1; image[51786]=1; image[51787]=1; image[51788]=1; image[51789]=1; image[51790]=1; image[51791]=1; image[51792]=1; image[51793]=1; image[51794]=1; image[51795]=1; image[51796]=1; image[51797]=1; image[51798]=1; image[51799]=1; image[51800]=2; image[51801]=2; image[51802]=2; image[51803]=2; image[51804]=2; image[51805]=1; image[51806]=2; image[51807]=2; image[51808]=4; image[51809]=4; image[51810]=3; image[51811]=4; image[51812]=4; image[51813]=4; image[51814]=5; image[51815]=5; image[51816]=6; image[51817]=8; image[51818]=9; image[51819]=8; image[51820]=8; image[51821]=9; image[51822]=11; image[51823]=14; image[51824]=15; image[51825]=16; image[51826]=16; image[51827]=16; image[51828]=16; image[51829]=8; image[51830]=6; image[51831]=11; image[51832]=15; image[51833]=15; image[51834]=19; image[51835]=15; image[51836]=16; image[51837]=23; image[51838]=21; image[51839]=21; image[51840]=26; image[51841]=22; image[51842]=14; image[51843]=6; image[51844]=4; image[51845]=4; image[51846]=17; image[51847]=46; image[51848]=40; image[51849]=24; image[51850]=26; image[51851]=38; image[51852]=38; image[51853]=36; image[51854]=35; image[51855]=34; image[51856]=35; image[51857]=36; image[51858]=36; image[51859]=38; image[51860]=37; image[51861]=39; image[51862]=40; image[51863]=41; image[51864]=44; image[51865]=37; image[51866]=21; image[51867]=13; image[51868]=16; image[51869]=35; image[51870]=57; image[51871]=58; image[51872]=69; image[51873]=76; image[51874]=65; image[51875]=52; image[51876]=38; image[51877]=34; image[51878]=13; image[51879]=6; image[51880]=3; image[51881]=1; image[51882]=1; image[51883]=1; image[51884]=0; image[51885]=1; image[51886]=1; image[51887]=1; image[51888]=1; image[51889]=1; image[51890]=1; image[51891]=1; image[51892]=1; image[51893]=1; image[51894]=0; image[51895]=1; image[51896]=1; image[51897]=0; image[51898]=1; image[51899]=1; image[51900]=1; image[51901]=1; image[51902]=1; image[51903]=1; image[51904]=1; image[51905]=1; image[51906]=1; image[51907]=1; image[51908]=0; image[51909]=0; image[51910]=0; image[51911]=0; image[51912]=0; image[51913]=1; image[51914]=0; image[51915]=0; image[51916]=0; image[51917]=1; image[51918]=1; image[51919]=1; image[51920]=1; image[51921]=1; image[51922]=1; image[51923]=1; image[51924]=1; image[51925]=1; image[51926]=0; image[51927]=1; image[51928]=0; image[51929]=1; image[51930]=1; image[51931]=1; image[51932]=1; image[51933]=0; image[51934]=1; image[51935]=1; image[51936]=1; image[51937]=0; image[51938]=1; image[51939]=1;

// Acquiring Data
d0=V(Data0)	;
d1=V(Data1)	;
d2=V(Data2)	;
d3=V(Data3)	;
d4=V(Data4)	;
d5=V(Data5)	;
d6=V(Data6)	;
d7=V(Data7)	;
d8=V(Data8)	;
d9=V(Data9)	;
d10=V(Data10)	;
d11=V(Data11)	;
d12=V(Data12)	;
d13=V(Data13)	;
d14=V(Data14)	;
d15=V(Data15)	;

// Calculating Gamma
d0=(d0>1.5);
d1=(d1>1.5);
d2=(d2>1.5);
d3=(d3>1.5);
d4=(d4>1.5);
d5=(d5>1.5);
d6=(d6>1.5);
d7=(d7>1.5);
d8=(d8>1.5);
d9=(d9>1.5);
d10=(d10>1.5);
d11=(d11>1.5);
d12=(d12>1.5);
d13=(d13>1.5);
d14=(d14>1.5);
d15=(d15>1.5);

gamma=d0+(2*d1)+(4*d2)+(8*d3)+(16*d4)+(32*d5)+(64*d6)+(128*d7)+(256*d8)+(512*d9)+(1024*d10)+(2048*d11)+(4096*d12)+(8192*d13)+(16384*d14)+(32768*d15);

// Performing Gamma Transformation on Image
gammafraction=gamma/10000;
for (counter=1; counter<=imagepixels; counter=counter+1) begin
r_image=(image[counter])/255;
d_image=pow(r_image, gammafraction);
p_image[counter]=255*d_image;
end

$display("*************************************");
$display("Double Type Image: ", r_image);
$display("Gamma/10000: ", gammafraction);
$display("Original Image[47]:", image[47]);
$display("gamma:", gamma);
$display("Processed Image[47]:", p_image[47]);

x=1.8;

end

// When Req signal is reset
@(cross (V(Req)-0.2,-1))	begin

x=0;

end

// When Ready signal is set
@(cross (V(Ready)-1.6,+1))	begin

//Calculating Standard Deviation
average=0;

for (counter=1; counter<=imagepixels; counter=counter+1) begin
average=average+p_image[counter];
end

average=average/imagepixels;

std=0;

for (counter=1; counter<=imagepixels; counter=counter+1) begin
std=std+pow((p_image[counter]-average),2);
end

std=std/imagepixels;
std=sqrt(std);

//Calculating Entropy
entropy=0;
pixel=0;

for (counter2=0; counter2<=255; counter2=counter2+1) begin

for (counter=1; counter<=imagepixels; counter=counter+1) begin
if ((p_image[counter]>=(counter2-0.5))&&(p_image[counter]<(counter2+0.5)))
pixel=pixel+1;
end

pixel=pixel/imagepixels;
entropy=entropy-(pixel*(log(pixel)/log(2)));
end

//Calculating Sobel
row=1;
sobel=0;

for (counter=1; counter<=imagepixels; counter=counter+1) begin

vsobel=0;
hsobel=0;

if (counter>(row*imagecolumns)) row=row+1;

//vertical sobel
if (row>1) begin
if ((counter-((row-1)*imagecolumns)>1)&&(counter-((row-1)*imagecolumns)<imagecolumns)) vsobel=vsobel-(p_image[counter-(imagecolumns+1)]+(2*p_image[counter-imagecolumns])+p_image[counter-(imagecolumns-1)]);
if (counter-((row-1)*imagecolumns)==1) vsobel=vsobel-((2*p_image[counter-imagecolumns])+p_image[counter-(imagecolumns-1)]);
if (counter-((row-1)*imagecolumns)==imagecolumns) vsobel=vsobel-(p_image[counter-(imagecolumns+1)]+(2*p_image[counter-imagecolumns]));
end

if (row<imagerows) begin
if ((counter-((row-1)*imagecolumns)>1)&&(counter-((row-1)*imagecolumns)<imagecolumns)) vsobel=vsobel+(p_image[counter+(imagecolumns+1)]+(2*p_image[counter+imagecolumns])+p_image[counter+(imagecolumns-1)]);
if (counter-((row-1)*imagecolumns)==1) vsobel=vsobel+((2*p_image[counter+imagecolumns])+p_image[counter+(imagecolumns+1)]);
if (counter-((row-1)*imagecolumns)==imagecolumns) vsobel=vsobel+(p_image[counter+(imagecolumns-1)]+(2*p_image[counter+imagecolumns]));
end

//horizontal sobel
if (counter-((row-1)*imagecolumns)>1) begin
if ((row>1)&&(row<imagerows))  hsobel=hsobel-(p_image[counter-(imagecolumns+1)]+(2*p_image[counter-1])+p_image[counter+(imagecolumns-1)]);
if (row==1) hsobel=hsobel-((2*p_image[counter-1])+p_image[counter+(imagecolumns-1)]);
if (row==imagerows) hsobel=hsobel-(p_image[counter-(imagecolumns+1)]+(2*p_image[counter-1]));
end

if (counter-((row-1)*imagecolumns)<imagecolumns) begin
if ((row>1)&&(row<imagerows))  hsobel=hsobel+(p_image[counter-(imagecolumns-1)]+(2*p_image[counter+1])+p_image[counter+(imagecolumns+1)]);
if (row==1) hsobel=hsobel+((2*p_image[counter+1])+p_image[counter+(imagecolumns+1)]);
if (row==imagerows) hsobel=hsobel+(p_image[counter-(imagecolumns-1)]+(2*p_image[counter+1]));
end

sobel=sobel+(abs(hsobel)+abs(vsobel));
end

sobel=sobel/imagepixels;

//Calculating Fitness
p_fitness=sobel*std*entropy;
onethird=0.333333;
fitness=1000*pow(p_fitness,onethird);

$display("****");
$display("Average:", average);
$display("STD:", std);
$display("Entropy:", entropy);
$display("Sobel:", sobel);
$display("p_fitness:", p_fitness);
$display("Fitness:", fitness);

y=1.8;

end

// Output fitness data
V(Out15) <+	transition(1.8*(fitness>=32768),100p,100p,100p);
V(Out14) <+	transition(1.8*((fitness%32768)>=16384),100p,100p,100p);
V(Out13) <+	transition(1.8*((fitness%16384)>=8192),100p,100p,100p);
V(Out12) <+	transition(1.8*((fitness%8192)>=4096),100p,100p,100p);
V(Out11) <+	transition(1.8*((fitness%4096)>=2048),100p,100p,100p);
V(Out10) <+	transition(1.8*((fitness%2048)>=1024),100p,100p,100p);
V(Out9) <+	transition(1.8*((fitness%1024)>=512),100p,100p,100p);
V(Out8) <+	transition(1.8*((fitness%512)>=256),100p,100p,100p);
V(Out7) <+	transition(1.8*((fitness%256)>=128),100p,100p,100p);
V(Out6) <+	transition(1.8*((fitness%128)>=64),100p,100p,100p);
V(Out5) <+	transition(1.8*((fitness%64)>=32),100p,100p,100p);
V(Out4) <+	transition(1.8*((fitness%32)>=16),100p,100p,100p);
V(Out3) <+	transition(1.8*((fitness%16)>=8),100p,100p,100p);
V(Out2) <+	transition(1.8*((fitness%8)>=4),100p,100p,100p);
V(Out1) <+	transition(1.8*((fitness%4)>=2),100p,100p,100p);
V(Out0) <+	transition(1.8*((fitness%2)>=1),100p,100p,100p);

// When Ready signal is reset
@(cross (V(Ready)-0.2,-1))	begin

y=0	;

end

// Acknowledge signal in the handshake mechanism
V(Ack) <+ transition(y,200p,50p,50p)	;
V(Ack) <+ transition(x,200p,50p,50p)	;

end

endmodule
